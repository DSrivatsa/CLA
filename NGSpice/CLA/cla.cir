* 5-bit CLA Adder
.include TSMC_180nm.txt
.param SUPPLY = 1.8
.param LAMBDA = 0.09u
* width is the universal width parameter - 10*LAMBDA
.param width = {10*LAMBDA}
.global gnd vdd

* NOT gate
.subckt inverter in out width
    MP out in vdd vdd CMOSP W={(2*width)} L={2*LAMBDA}
    + AS={5*(2*width)*LAMBDA} PS={10*LAMBDA+2*(2*width)} AD={5*(2*width)*LAMBDA} PD={10*LAMBDA+2*(2*width)}

    MN out in gnd gnd CMOSN W={(width)} L={2*LAMBDA}
    + AS={5*(width)*LAMBDA} PS={10*LAMBDA+2*(width)} AD={5*(width)*LAMBDA} PD={10*LAMBDA+2*(width)}
.ends inverter

.subckt inverterLoad in out width
    MP out in vdd vdd CMOSP W={(width)} L={2*LAMBDA}
    + AS={5*(width)*LAMBDA} PS={10*LAMBDA+2*(width)} AD={5*(width)*LAMBDA} PD={10*LAMBDA+2*(width)}

    MN out in gnd gnd CMOSN W={(width/2)} L={2*LAMBDA}
    + AS={5*(width/2)*LAMBDA} PS={10*LAMBDA+2*(width/2)} AD={5*(width/2)*LAMBDA} PD={10*LAMBDA+2*(width/2)}
.ends inverterLoad

* NAND gate
.subckt nand in_1 in_2 out width
    MP1 out in_1 vdd vdd CMOSP W={(2*width)} L={2*LAMBDA}
    + AS={5*(2*width)*LAMBDA} PS={10*LAMBDA+2*(2*width)} AD={5*(2*width)*LAMBDA} PD={10*LAMBDA+2*(2*width)}

    MP2 out in_2 vdd vdd CMOSP W={(2*width)} L={2*LAMBDA}
    + AS={5*(2*width)*LAMBDA} PS={10*LAMBDA+2*(2*width)} AD={5*(2*width)*LAMBDA} PD={10*LAMBDA+2*(2*width)}

    MN1 out in_1 temp1 gnd CMOSN W={(2*width)} L={2*LAMBDA}
    + AS={5*(2*width)*LAMBDA} PS={10*LAMBDA+2*(2*width)} AD={5*(2*width)*LAMBDA} PD={10*LAMBDA+2*(2*width)}

    MN2 temp1 in_2 gnd gnd CMOSN W={(2*width)} L={2*LAMBDA}
    + AS={5*(2*width)*LAMBDA} PS={10*LAMBDA+2*(2*width)} AD={5*(2*width)*LAMBDA} PD={10*LAMBDA+2*(2*width)}
.ends nand

* NOR gate
.subckt nor in_1 in_2 out width
    MP1 temp1 in_1 vdd vdd CMOSP W={(2*width)} L={2*LAMBDA}
    + AS={5*(2*width)*LAMBDA} PS={10*LAMBDA+2*(2*width)} AD={5*(2*width)*LAMBDA} PD={10*LAMBDA+2*(2*width)}

    MP2 out in_2 temp1 vdd CMOSP W={(2*width)} L={2*LAMBDA}
    + AS={5*(2*width)*LAMBDA} PS={10*LAMBDA+2*(2*width)} AD={5*(2*width)*LAMBDA} PD={10*LAMBDA+2*(2*width)}

    MN1 out in_1 gnd gnd CMOSN W={(2*width)} L={2*LAMBDA}
    + AS={5*(2*width)*LAMBDA} PS={10*LAMBDA+2*(2*width)} AD={5*(2*width)*LAMBDA} PD={10*LAMBDA+2*(2*width)}

    MN2 out in_2 gnd gnd CMOSN W={(2*width)} L={2*LAMBDA}
    + AS={5*(2*width)*LAMBDA} PS={10*LAMBDA+2*(2*width)} AD={5*(2*width)*LAMBDA} PD={10*LAMBDA+2*(2*width)}
.ends nor

* XOR gate
.subckt xor in_1 in_2 out width
    X1 in_1 in_1_inv width inverter
    M1 out in_2 in_1 vdd CMOSP W={(2*width)} L={2*LAMBDA}
    + AS={5*(2*width)*LAMBDA} PS={10*LAMBDA+2*(2*width)}
    + AD={5*(2*width)*LAMBDA} PD={10*LAMBDA+2*(2*width)}

    M2 out in_2 in_1_inv gnd CMOSN W={(width)} L={2*LAMBDA}
    + AS={5*(width)*LAMBDA} PS={10*LAMBDA+2*(width)}
    + AD={5*(width)*LAMBDA} PD={10*LAMBDA+2*(width)}

    M3 out in_1 in_2 vdd CMOSP W={(2*width)} L={2*LAMBDA}
    + AS={5*(2*width)*LAMBDA} PS={10*LAMBDA+2*(2*width)}
    + AD={5*(2*width)*LAMBDA} PD={10*LAMBDA+2*(2*width)}

    M4 in_2 in_1_inv out gnd CMOSN W={(width)} L={2*LAMBDA}
    + AS={5*(width)*LAMBDA} PS={10*LAMBDA+2*(width)}
    + AD={5*(width)*LAMBDA} PD={10*LAMBDA+2*(width)}
.ends xor

* OR gate
.subckt or in_1 in_2 out width
    * NOR gate
    MP1 temp1 in_1 vdd vdd CMOSP W={(2*width)} L={2*LAMBDA}
    + AS={5*(2*width)*LAMBDA} PS={10*LAMBDA+2*(2*width)} AD={5*(2*width)*LAMBDA} PD={10*LAMBDA+2*(2*width)}
    MP2 out1 in_2 temp1 vdd CMOSP W={(2*width)} L={2*LAMBDA}
    + AS={5*(2*width)*LAMBDA} PS={10*LAMBDA+2*(2*width)} AD={5*(2*width)*LAMBDA} PD={10*LAMBDA+2*(2*width)}
    MN1 out1 in_1 gnd gnd CMOSN W={(2*width)} L={2*LAMBDA}
    + AS={5*(2*width)*LAMBDA} PS={10*LAMBDA+2*(2*width)} AD={5*(2*width)*LAMBDA} PD={10*LAMBDA+2*(2*width)}
    MN2 out1 in_2 gnd gnd CMOSN W={(2*width)} L={2*LAMBDA}
    + AS={5*(2*width)*LAMBDA} PS={10*LAMBDA+2*(2*width)} AD={5*(2*width)*LAMBDA} PD={10*LAMBDA+2*(2*width)}

    * Inverter
    MP3 out out1 vdd vdd CMOSP W={(2*width)} L={2*LAMBDA}
    + AS={5*(2*width)*LAMBDA} PS={10*LAMBDA+2*(2*width)} AD={5*(2*width)*LAMBDA} PD={10*LAMBDA+2*(2*width)}
    MN3 out out1 gnd gnd CMOSN W={(width)} L={2*LAMBDA}
    + AS={5*(width)*LAMBDA} PS={10*LAMBDA+2*(width)} AD={5*(width)*LAMBDA} PD={10*LAMBDA+2*(width)}
.ends or

* AND gate
.subckt and in_1 in_2 out width
    * NAND gate
    MP1 out1 in_1 vdd vdd CMOSP W={(2*width)} L={2*LAMBDA}
    + AS={5*(2*width)*LAMBDA} PS={10*LAMBDA+2*(2*width)} AD={5*(2*width)*LAMBDA} PD={10*LAMBDA+2*(2*width)}
    MP2 out1 in_2 vdd vdd CMOSP W={(2*width)} L={2*LAMBDA}
    + AS={5*(2*width)*LAMBDA} PS={10*LAMBDA+2*(2*width)} AD={5*(2*width)*LAMBDA} PD={10*LAMBDA+2*(2*width)}
    MN1 out1 in_1 temp1 gnd CMOSN W={(2*width)} L={2*LAMBDA}
    + AS={5*(2*width)*LAMBDA} PS={10*LAMBDA+2*(2*width)} AD={5*(2*width)*LAMBDA} PD={10*LAMBDA+2*(2*width)}
    MN2 temp1 in_2 gnd gnd CMOSN W={(2*width)} L={2*LAMBDA}
    + AS={5*(2*width)*LAMBDA} PS={10*LAMBDA+2*(2*width)} AD={5*(2*width)*LAMBDA} PD={10*LAMBDA+2*(2*width)}

    * Inverter
    MP3 out out1 vdd vdd CMOSP W={(2*width)} L={2*LAMBDA}
    + AS={5*(2*width)*LAMBDA} PS={10*LAMBDA+2*(2*width)} AD={5*(2*width)*LAMBDA} PD={10*LAMBDA+2*(2*width)}
    MN3 out out1 gnd gnd CMOSN W={(width)} L={2*LAMBDA}
    + AS={5*(width)*LAMBDA} PS={10*LAMBDA+2*(width)} AD={5*(width)*LAMBDA} PD={10*LAMBDA+2*(width)}
.ends and

* Bit 0
X1 a0 b0 g0_inv width nand
X2 a0 b0 p0_inv width nor
X3 a0 b0 mid_s0 width xor
X4 mid_s0 c0 s0 width xor

* C1 = (G0' . (P0' + C0'))'
X6 c0 c0_inv width inverter
X7 p0_inv c0_inv temp100 width or
X8 temp100 g0_inv c1 width nand

* Bit 1
X9 a1 b1 g1_inv width nand
X10 a1 b1 p1_inv width nor
X11 a1 b1 mid_s1 width xor
X12 mid_s1 c1 s1 width xor

* (P1' + p0')C0
X13 p1_inv p0_inv temp101 width nor
X14 temp101 c0 temp102 width and

* (G1' (P1' + G0'))'
X15 g0_inv p1_inv temp103 width or
X16 temp103 g1_inv temp104 width nand

* C2 = (G1' (P1' + G0'))' + (P1' + p0')C0
X17 temp104 temp102 c2 width or

* Bit 2
X18 a2 b2 g2_inv width nand
X19 a2 b2 p2_inv width nor
X20 a2 b2 mid_s2 width xor
X21 mid_s2 c2 s2 width xor

* (P2' + p1')C1
X22 p1_inv p2_inv temp105 width nor
X23 temp105 c1 temp106 width and

* (G2' (P2' + G1'))'
X24 g1_inv p2_inv temp107 width or
X25 temp107 g2_inv temp108 width nand

* C3 = (G2' (P2' + G1'))' + (P2' + p1')C1
X26 temp108 temp106 c3 width or

* Bit 3
X27 a3 b3 g3_inv width nand
X28 a3 b3 p3_inv width nor
X29 a3 b3 mid_s3 width xor
X30 mid_s3 c3 s3 width xor

* P4 (or Pout for 4-bit group)
X31 p3_inv p2_inv temp109 width nor
X32 temp109 temp101 p4 width and

* G4 (or Gout for 4-bit group)
* (P3' + P2')' * (G1' (P1' + G0'))' = temp109 * temp104
X33 temp104 temp109 temp110 width and

* (G3' (P3' + G2'))'
X34 g2_inv p3_inv temp111 width or
X35 temp111 g3_inv temp112 width nand

* G4 = (G3' (P3' + G2'))' + (P3' + P2')' * (G1' (P1' + G0'))'
X36 temp112 temp110 g4_inv width nor

* C4 (or Cout from 4-bit) = (G4_inv . (P4 . C0)')'
X37 p4 c0 temp113 width nand
X38 temp113 g4_inv c4 width nand

* === BIT 4 (5th bit) ===

* Bit 4: Generate and Propagate
X39 a4 b4 gen4_inv width nand
X40 a4 b4 prop4_inv width nor

* Bit 4: Sum = a4 XOR b4 XOR c4
X41 a4 b4 mid_s4 width xor
X42 mid_s4 c4 s4 width xor

* C5 = (gen4_inv . (prop4_inv + c4_inv))'
X43 c4 c4_inv width inverter
X44 prop4_inv c4_inv temp114 width or
X45 temp114 gen4_inv c5 width nand

* Output Loads
X100 s0 s0_load width inverterLoad
X101 s1 s1_load width inverterLoad
X102 s2 s2_load width inverterLoad
X103 s3 s3_load width inverterLoad
X104 s4 s4_load width inverterLoad
X105 c5 c5_load width inverterLoad

* Power Supply
Vdd vdd gnd 'SUPPLY'

* INPUT VOLTAGE SOURCES (Example: 11111 + 01111 +0 = 101110)
Va0 a0 gnd pulse 0 1.8 1ns 10ps 10ps 100n 200ns
Va1 a1 gnd pulse 0 1.8 1ns 10ps 10ps 100n 200ns
Va2 a2 gnd pulse 0 1.8 1ns 10ps 10ps 100n 200ns
Va3 a3 gnd pulse 0 1.8 1ns 10ps 10ps 100n 200ns
Va4 a4 gnd pulse 0 1.8 1ns 10ps 10ps 100n 200ns

Vb0 b0 gnd pulse 0 1.8 1ns 10ps 10ps 100n 200ns
Vb1 b1 gnd pulse 0 1.8 1ns 10ps 10ps 100n 200ns
Vb2 b2 gnd pulse 0 1.8 1ns 10ps 10ps 100n 200ns
Vb3 b3 gnd pulse 0 1.8 1ns 10ps 10ps 100n 200ns
Vb4 b4 gnd pulse 1.8 0 1ns 10ps 10ps 100n 200ns

Vc0 c0 gnd pulse 1.8 0 1ns 10ps 10ps 100n 200ns

* Propagation delay from a0 to s4 (MSB of sum) - Critical Path
.measure tran tpd_rise_s4
+ TRIG v(a0) VAL='0.5*SUPPLY' RISE=1
+ TARG v(s4) VAL='0.5*SUPPLY' RISE=1

.measure tran tpd_fall_s4
+ TRIG v(a0) VAL='0.5*SUPPLY' FALL=1
+ TARG v(s4) VAL='0.5*SUPPLY' FALL=1

.measure tran tpd_s4 param = '(tpd_rise_s4 + tpd_fall_s4)/2'

* Propagation delay from a0 to c5 (Carry out)
.measure tran tpd_rise_c5
+ TRIG v(a0) VAL='0.5*SUPPLY' RISE=1
+ TARG v(c5) VAL='0.5*SUPPLY' RISE=1

.measure tran tpd_fall_c5
+ TRIG v(a0) VAL='0.5*SUPPLY' FALL=1
+ TARG v(c5) VAL='0.5*SUPPLY' FALL=1

.measure tran tpd_c5 param = '(tpd_rise_c5 + tpd_fall_c5)/2'

* Overall propagation delay (worst case between s4 and c5)
.measure tran tpd_max param = 'max(tpd_s4, tpd_c5)'

* Rise and Fall times for s4
.measure tran trise_s4
+ TRIG v(s4) VAL='0.1*SUPPLY' RISE=1
+ TARG v(s4) VAL='0.9*SUPPLY' RISE=1

.measure tran tfall_s4
+ TRIG v(s4) VAL='0.9*SUPPLY' FALL=1
+ TARG v(s4) VAL='0.1*SUPPLY' FALL=1

* Average power consumption
.measure tran avg_power avg p(vdd) from=0ns to=200ns

* Peak power consumption
.measure tran peak_power max p(vdd) from=0ns to=200ns

* Energy per operation (integrate power over one complete cycle)
.measure tran energy_per_cycle integ p(vdd) from=1ns to=201ns

* Static power (measure during stable period)
.measure tran static_power avg p(vdd) from=50ns to=100ns

* Dynamic power (total - static)
.measure tran dynamic_power param='avg_power - static_power'

* Power-Delay Product (PDP)
.measure tran pdp param='avg_power * tpd_max'

* Energy-Delay Product (EDP)
.measure tran edp param='energy_per_cycle * tpd_max'

.tran 10p 200ns

.control
set hcopypscolor = 0
set color0=white
set color1=black

run

set curplottitle="CLA 2025122009"

plot v(a0), v(a1)+2, v(a2)+4, v(a3)+6, v(a4)+8
plot v(b0), v(b1)+2, v(b2)+4, v(b3)+6, v(b4)+8, v(c0)+10
plot v(s4)+8, v(s3)+6, v(s2)+4, v(s1)+2, v(s0), v(c5)+10

.endc
