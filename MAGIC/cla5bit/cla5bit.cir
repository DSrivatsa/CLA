* 5-bit CLA Magic Layout Verification
.include TSMC_180nm.txt
.param SUPPLY = 1.8
.option scale=90n
.global gnd vdd

* SPICE3 file created from cla5b.ext - technology: scmos

.option scale=90n

M1000 c0_inv c0 vdd w_88_314# CMOSP w=20 l=2
+  ad=100p pd=50u as=100p ps=50u
M1001 a_336_401# temp103 gnd Gnd CMOSN w=20 l=2
+  ad=80p pd=28u as=100p ps=50u
M1002 a_655_554# clk a_690_531# Gnd CMOSN w=20 l=2
+  ad=100p pd=50u as=70p ps=27u
M1003 a_182_138# a_183_113# vdd w_180_9# CMOSP w=20 l=2
+  ad=100p pd=50u as=100p ps=50u
M1004 s0_inv s0_out vdd w_4_335# CMOSP w=20 l=2
+  ad=100p pd=50u as=100p ps=50u
M1005 a_586_466# temp105 vdd w_573_460# CMOSP w=20 l=2
+  ad=80p pd=28u as=100p ps=50u
M1006 a_743_571# clk a_778_548# Gnd CMOSN w=20 l=2
+  ad=100p pd=50u as=70p ps=27u
M1007 a_880_69# a_880_43# gnd Gnd CMOSN w=20 l=2
+  ad=100p pd=50u as=100p ps=50u
M1008 mid_s0 c0 s0 w_17_273# CMOSP w=20 l=2
+  ad=100p pd=50u as=70p ps=27u
M1009 s0 a_28_249# c0 Gnd CMOSN w=10 l=2
+  ad=35p pd=17u as=50p ps=30u
M1010 a_100_67# clk a_104_43# w_98_6# CMOSP w=20 l=2
+  ad=100p pd=50u as=60p ps=26u
M1011 a_654_485# c4_in gnd Gnd CMOSN w=20 l=2
+  ad=100p pd=50u as=100p ps=50u
M1012 a_772_69# a_772_43# gnd Gnd CMOSN w=20 l=2
+  ad=100p pd=50u as=100p ps=50u
M1013 a_686_137# clk a_722_114# Gnd CMOSN w=20 l=2
+  ad=100p pd=50u as=70p ps=27u
M1014 p2_inv a2 gnd Gnd CMOSN w=10 l=2
+  ad=40p pd=18u as=50p ps=30u
M1015 a_602_43# a3_in gnd Gnd CMOSN w=20 l=2
+  ad=100p pd=50u as=100p ps=50u
M1016 a_384_115# a_349_113# gnd Gnd CMOSN w=20 l=2
+  ad=70p pd=27u as=100p ps=50u
M1017 a_352_22# b1_in vdd w_346_9# CMOSP w=20 l=2
+  ad=60p pd=26u as=100p ps=50u
M1018 a_837_618# clk a_873_595# Gnd CMOSN w=20 l=2
+  ad=100p pd=50u as=70p ps=27u
M1019 a_555_114# a_520_112# gnd Gnd CMOSN w=20 l=2
+  ad=70p pd=27u as=100p ps=50u
M1020 a_690_556# a_655_554# gnd Gnd CMOSN w=20 l=2
+  ad=70p pd=27u as=100p ps=50u
M1021 a_916_114# a_881_112# gnd Gnd CMOSN w=20 l=2
+  ad=70p pd=27u as=100p ps=50u
M1022 p0_inv a0 gnd Gnd CMOSN w=10 l=2
+  ad=40p pd=18u as=50p ps=30u
M1023 temp110 a_694_386# gnd Gnd CMOSN w=10 l=2
+  ad=50p pd=30u as=50p ps=30u
M1024 vdd a_640_359# temp110 w_628_378# CMOSP w=20 l=2
+  ad=100p pd=50u as=100p ps=50u
M1025 s2_inv s2_out vdd w_306_493# CMOSP w=20 l=2
+  ad=100p pd=50u as=100p ps=50u
M1026 a_881_87# a_880_69# vdd w_878_8# CMOSP w=20 l=2
+  ad=100p pd=50u as=100p ps=50u
M1027 a_778_573# a_743_571# gnd Gnd CMOSN w=20 l=2
+  ad=70p pd=27u as=100p ps=50u
M1028 a_773_87# a_772_69# vdd w_770_8# CMOSP w=20 l=2
+  ad=100p pd=50u as=100p ps=50u
M1029 a_470_90# a_435_88# gnd Gnd CMOSN w=20 l=2
+  ad=70p pd=27u as=100p ps=50u
M1030 a_689_223# p4 gnd Gnd CMOSN w=20 l=2
+  ad=80p pd=28u as=100p ps=50u
M1031 a_603_87# a_602_69# vdd w_600_8# CMOSP w=20 l=2
+  ad=100p pd=50u as=100p ps=50u
M1032 a_535_452# p1_inv vdd w_522_446# CMOSP w=40 l=2
+  ad=0.16n pd=48u as=0.2n ps=90u
M1033 a2 a_434_138# gnd Gnd CMOSN w=10 l=2
+  ad=50p pd=30u as=50p ps=30u
M1034 a_379_391# temp102 gnd Gnd CMOSN w=10 l=2
+  ad=40p pd=18u as=50p ps=30u
M1035 a_520_87# a_519_69# gnd Gnd CMOSN w=10 l=2
+  ad=50p pd=30u as=50p ps=30u
M1036 a_602_69# a_602_43# gnd Gnd CMOSN w=20 l=2
+  ad=100p pd=50u as=100p ps=50u
M1037 a_57_88# a_22_86# gnd Gnd CMOSN w=20 l=2
+  ad=70p pd=27u as=100p ps=50u
M1038 b3_inv b3 gnd Gnd CMOSN w=10 l=2
+  ad=50p pd=30u as=50p ps=30u
M1039 a_309_597# a_309_572# vdd w_306_493# CMOSP w=20 l=2
+  ad=100p pd=50u as=100p ps=50u
M1040 g2_inv a2 vdd w_372_189# CMOSP w=20 l=2
+  ad=80p pd=28u as=100p ps=50u
M1041 a_182_70# a_182_44# gnd Gnd CMOSN w=20 l=2
+  ad=100p pd=50u as=100p ps=50u
M1042 a_270_21# a1_in vdd w_264_8# CMOSP w=20 l=2
+  ad=60p pd=26u as=100p ps=50u
M1043 a_435_113# a_435_88# vdd w_432_9# CMOSP w=20 l=2
+  ad=100p pd=50u as=100p ps=50u
M1044 vdd temp113 c4_in w_676_255# CMOSP w=20 l=2
+  ad=100p pd=50u as=80p ps=28u
M1045 g1_inv b1 a_334_218# Gnd CMOSN w=20 l=2
+  ad=100p pd=50u as=80p ps=28u
M1046 gnd mid_s3 a_549_279# Gnd CMOSN w=10 l=2
+  ad=50p pd=30u as=50p ps=30u
M1047 vdd temp101 a_441_300# w_429_320# CMOSP w=20 l=2
+  ad=100p pd=50u as=80p ps=28u
M1048 a_266_43# clk a_270_21# w_264_8# CMOSP w=20 l=2
+  ad=100p pd=50u as=60p ps=26u
M1049 s1 mid_s1 c1 w_211_285# CMOSP w=20 l=2
+  ad=70p pd=27u as=100p ps=50u
M1050 b0 a_182_138# vdd w_180_9# CMOSP w=20 l=2
+  ad=100p pd=50u as=100p ps=50u
M1051 temp111 a_760_348# vdd w_747_370# CMOSP w=20 l=2
+  ad=100p pd=50u as=100p ps=50u
M1052 a_841_502# c5 vdd w_835_489# CMOSP w=20 l=2
+  ad=60p pd=26u as=100p ps=50u
M1053 mid_s2 b2 a2 w_372_189# CMOSP w=20 l=2
+  ad=70p pd=27u as=100p ps=50u
M1054 a_743_571# a_743_546# vdd w_740_467# CMOSP w=20 l=2
+  ad=100p pd=50u as=100p ps=50u
M1055 gnd temp106 a_430_473# Gnd CMOSN w=10 l=2
+  ad=50p pd=30u as=40p ps=18u
M1056 a_994_256# a_973_272# gnd Gnd CMOSN w=20 l=2
+  ad=80p pd=28u as=100p ps=50u
M1057 a_945_268# c4_inv a_945_296# w_908_310# CMOSP w=40 l=2
+  ad=0.2n pd=90u as=0.16n ps=48u
M1058 g3_inv a3 vdd w_524_189# CMOSP w=20 l=2
+  ad=80p pd=28u as=100p ps=50u
M1059 s3 c3 mid_s3 w_543_295# CMOSP w=20 l=2
+  ad=70p pd=27u as=100p ps=50u
M1060 b0_inv b0 vdd w_63_186# CMOSP w=20 l=2
+  ad=100p pd=50u as=100p ps=50u
M1061 a_270_45# a_266_43# vdd w_264_8# CMOSP w=20 l=2
+  ad=60p pd=26u as=100p ps=50u
M1062 a_140_171# a0 vdd w_63_186# CMOSP w=40 l=2
+  ad=0.16n pd=48u as=0.2n ps=90u
M1063 a_687_87# a_686_69# gnd Gnd CMOSN w=10 l=2
+  ad=50p pd=30u as=50p ps=30u
M1064 vdd b0 g0_inv w_63_186# CMOSP w=20 l=2
+  ad=100p pd=50u as=80p ps=28u
M1065 a_772_137# a_773_112# vdd w_770_8# CMOSP w=20 l=2
+  ad=100p pd=50u as=100p ps=50u
M1066 a_655_554# a_655_529# vdd w_652_450# CMOSP w=20 l=2
+  ad=100p pd=50u as=100p ps=50u
M1067 a_266_69# clk a_270_45# w_264_8# CMOSP w=20 l=2
+  ad=100p pd=50u as=60p ps=26u
M1068 a_501_317# p3_inv temp109 w_429_320# CMOSP w=40 l=2
+  ad=0.16n pd=48u as=0.2n ps=90u
M1069 a_602_137# clk a_638_114# Gnd CMOSN w=20 l=2
+  ad=100p pd=50u as=70p ps=27u
M1070 vdd p2_inv a_501_317# w_429_320# CMOSP w=40 l=2
+  ad=0.2n pd=90u as=0.16n ps=48u
M1071 mid_s3 b3 a3 w_524_189# CMOSP w=20 l=2
+  ad=70p pd=27u as=100p ps=50u
M1072 a_916_89# a_881_87# gnd Gnd CMOSN w=20 l=2
+  ad=70p pd=27u as=100p ps=50u
M1073 a_107_477# clk a_142_454# Gnd CMOSN w=20 l=2
+  ad=100p pd=50u as=70p ps=27u
M1074 a_808_89# a_773_87# gnd Gnd CMOSN w=20 l=2
+  ad=70p pd=27u as=100p ps=50u
M1075 a_308_622# a_309_597# vdd w_306_493# CMOSP w=20 l=2
+  ad=100p pd=50u as=100p ps=50u
M1076 a_746_480# s4 vdd w_740_467# CMOSP w=20 l=2
+  ad=60p pd=26u as=100p ps=50u
M1077 a_511_616# clk a_515_594# w_509_581# CMOSP w=20 l=2
+  ad=100p pd=50u as=60p ps=26u
M1078 b0_inv a0 mid_s0 Gnd CMOSN w=10 l=2
+  ad=50p pd=30u as=35p ps=17u
M1079 temp113 p4 vdd w_676_255# CMOSP w=20 l=2
+  ad=80p pd=28u as=100p ps=50u
M1080 a_848_245# mid_s4 gnd Gnd CMOSN w=10 l=2
+  ad=50p pd=30u as=50p ps=30u
M1081 a_434_44# a2_in gnd Gnd CMOSN w=20 l=2
+  ad=100p pd=50u as=100p ps=50u
M1082 a1 a_266_137# gnd Gnd CMOSN w=10 l=2
+  ad=50p pd=30u as=50p ps=30u
M1083 s2 c2 mid_s2 w_348_337# CMOSP w=20 l=2
+  ad=70p pd=27u as=100p ps=50u
M1084 temp101 p1_inv gnd Gnd CMOSN w=10 l=2
+  ad=40p pd=18u as=50p ps=30u
M1085 gnd p0_inv temp101 Gnd CMOSN w=10 l=2
+  ad=50p pd=30u as=40p ps=18u
M1086 a_222_261# mid_s1 gnd Gnd CMOSN w=10 l=2
+  ad=50p pd=30u as=50p ps=30u
M1087 a_742_502# clk a_746_480# w_740_467# CMOSP w=20 l=2
+  ad=100p pd=50u as=60p ps=26u
M1088 a_182_138# clk a_218_115# Gnd CMOSN w=20 l=2
+  ad=100p pd=50u as=70p ps=27u
M1089 a_734_309# temp110 g4_inv w_728_296# CMOSP w=40 l=2
+  ad=0.16n pd=48u as=0.2n ps=90u
M1090 a_231_438# p1_inv a_259_438# w_251_453# CMOSP w=40 l=2
+  ad=0.2n pd=90u as=0.16n ps=48u
M1091 c3 a_549_279# s3 Gnd CMOSN w=10 l=2
+  ad=50p pd=30u as=35p ps=17u
M1092 a_183_88# a_182_70# gnd Gnd CMOSN w=10 l=2
+  ad=50p pd=30u as=50p ps=30u
M1093 c5 g4_inv a_994_256# Gnd CMOSN w=20 l=2
+  ad=100p pd=50u as=80p ps=28u
M1094 a_638_89# a_603_87# gnd Gnd CMOSN w=20 l=2
+  ad=70p pd=27u as=100p ps=50u
M1095 c5_out a_837_618# vdd w_835_489# CMOSP w=20 l=2
+  ad=100p pd=50u as=100p ps=50u
M1096 a_438_22# a2_in vdd w_432_9# CMOSP w=20 l=2
+  ad=60p pd=26u as=100p ps=50u
M1097 gnd temp101 a_464_294# Gnd CMOSN w=20 l=2
+  ad=100p pd=50u as=80p ps=28u
M1098 a_218_90# a_183_88# gnd Gnd CMOSN w=20 l=2
+  ad=70p pd=27u as=100p ps=50u
M1099 p1_inv a1 gnd Gnd CMOSN w=10 l=2
+  ad=40p pd=18u as=50p ps=30u
M1100 a_308_554# a_308_528# gnd Gnd CMOSN w=20 l=2
+  ad=100p pd=50u as=100p ps=50u
M1101 s1_inv s1_out vdd w_104_373# CMOSP w=20 l=2
+  ad=100p pd=50u as=100p ps=50u
M1102 gnd temp109 a_640_359# Gnd CMOSN w=10 l=2
+  ad=50p pd=30u as=40p ps=18u
M1103 a_348_70# a_348_44# gnd Gnd CMOSN w=20 l=2
+  ad=100p pd=50u as=100p ps=50u
M1104 gnd b1 p1_inv Gnd CMOSN w=10 l=2
+  ad=50p pd=30u as=40p ps=18u
M1105 a_723_223# g4_inv gnd Gnd CMOSN w=20 l=2
+  ad=80p pd=28u as=100p ps=50u
M1106 a_776_139# a_772_137# vdd w_770_8# CMOSP w=20 l=2
+  ad=100p pd=50u as=100p ps=50u
M1107 gnd g2_inv a_760_348# Gnd CMOSN w=10 l=2
+  ad=50p pd=30u as=40p ps=18u
M1108 a_654_485# clk a_658_463# w_652_450# CMOSP w=20 l=2
+  ad=100p pd=50u as=60p ps=26u
M1109 a_880_137# a_881_112# vdd w_878_8# CMOSP w=20 l=2
+  ad=100p pd=50u as=100p ps=50u
M1110 a_602_137# a_603_112# vdd w_600_8# CMOSP w=20 l=2
+  ad=100p pd=50u as=100p ps=50u
M1111 c5 a_973_272# vdd w_908_310# CMOSP w=20 l=2
+  ad=80p pd=28u as=100p ps=50u
M1112 a_101_110# clk a_136_87# Gnd CMOSN w=20 l=2
+  ad=100p pd=50u as=70p ps=27u
M1113 vdd g0_inv c1 w_88_314# CMOSP w=20 l=2
+  ad=100p pd=50u as=80p ps=28u
M1114 b1_inv a1 mid_s1 Gnd CMOSN w=10 l=2
+  ad=50p pd=30u as=35p ps=17u
M1115 vdd mid_s3 a_549_279# w_543_295# CMOSP w=20 l=2
+  ad=100p pd=50u as=100p ps=50u
M1116 a_106_502# clk a_142_479# Gnd CMOSN w=20 l=2
+  ad=100p pd=50u as=70p ps=27u
M1117 a_107_477# a_107_452# vdd w_104_373# CMOSP w=20 l=2
+  ad=100p pd=50u as=100p ps=50u
M1118 gnd c0_inv a_125_272# Gnd CMOSN w=10 l=2
+  ad=50p pd=30u as=40p ps=18u
M1119 gnd p1_inv a_231_438# Gnd CMOSN w=10 l=2
+  ad=50p pd=30u as=40p ps=18u
M1120 a_136_112# a_101_110# gnd Gnd CMOSN w=20 l=2
+  ad=70p pd=27u as=100p ps=50u
M1121 a_658_487# a_654_485# vdd w_652_450# CMOSP w=20 l=2
+  ad=60p pd=26u as=100p ps=50u
M1122 c5_inv c5_out vdd w_835_489# CMOSP w=20 l=2
+  ad=100p pd=50u as=100p ps=50u
M1123 gnd a_441_300# p4 Gnd CMOSN w=10 l=2
+  ad=50p pd=30u as=50p ps=30u
M1124 a_267_112# a_267_87# vdd w_264_8# CMOSP w=20 l=2
+  ad=100p pd=50u as=100p ps=50u
M1125 temp106 a_586_466# gnd Gnd CMOSN w=10 l=2
+  ad=50p pd=30u as=50p ps=30u
M1126 a_654_511# clk a_658_487# w_652_450# CMOSP w=20 l=2
+  ad=100p pd=50u as=60p ps=26u
M1127 a_104_19# a0_in vdd w_98_6# CMOSP w=20 l=2
+  ad=60p pd=26u as=100p ps=50u
M1128 a_21_136# clk a_57_113# Gnd CMOSN w=20 l=2
+  ad=100p pd=50u as=70p ps=27u
M1129 g4_inv temp110 gnd Gnd CMOSN w=10 l=2
+  ad=40p pd=18u as=50p ps=30u
M1130 a_538_529# p2_inv a_538_519# w_532_506# CMOSP w=40 l=2
+  ad=0.2n pd=90u as=0.16n ps=48u
M1131 a_848_245# mid_s4 vdd w_837_269# CMOSP w=20 l=2
+  ad=100p pd=50u as=100p ps=50u
M1132 s0_out a_6_464# vdd w_4_335# CMOSP w=20 l=2
+  ad=100p pd=50u as=100p ps=50u
M1133 a_470_115# a_435_113# gnd Gnd CMOSN w=20 l=2
+  ad=70p pd=27u as=100p ps=50u
M1134 a_520_112# clk a_555_89# Gnd CMOSN w=20 l=2
+  ad=100p pd=50u as=70p ps=27u
M1135 a_100_41# clk a_104_19# w_98_6# CMOSP w=20 l=2
+  ad=100p pd=50u as=60p ps=26u
M1136 b1_inv b1 vdd w_223_186# CMOSP w=20 l=2
+  ad=100p pd=50u as=100p ps=50u
M1137 vdd temp106 a_450_500# w_419_492# CMOSP w=40 l=2
+  ad=0.2n pd=90u as=0.16n ps=48u
M1138 b2_inv b2 gnd Gnd CMOSN w=10 l=2
+  ad=50p pd=30u as=50p ps=30u
M1139 a_300_171# a1 vdd w_223_186# CMOSP w=40 l=2
+  ad=0.16n pd=48u as=0.2n ps=90u
M1140 p1_inv b1 a_300_171# w_223_186# CMOSP w=40 l=2
+  ad=0.2n pd=90u as=0.16n ps=48u
M1141 a_100_135# clk a_136_112# Gnd CMOSN w=20 l=2
+  ad=100p pd=50u as=70p ps=27u
M1142 s3_inv s3_out vdd w_509_581# CMOSP w=20 l=2
+  ad=100p pd=50u as=100p ps=50u
M1143 s2_out a_308_622# vdd w_306_493# CMOSP w=20 l=2
+  ad=100p pd=50u as=100p ps=50u
M1144 a_104_43# a_100_41# vdd w_98_6# CMOSP w=20 l=2
+  ad=60p pd=26u as=100p ps=50u
M1145 b4 a_880_137# vdd w_878_8# CMOSP w=20 l=2
+  ad=100p pd=50u as=100p ps=50u
M1146 a_110_386# s1 vdd w_104_373# CMOSP w=20 l=2
+  ad=60p pd=26u as=100p ps=50u
M1147 a_772_137# clk a_808_114# Gnd CMOSN w=20 l=2
+  ad=100p pd=50u as=70p ps=27u
M1148 a3 a_602_137# vdd w_600_8# CMOSP w=20 l=2
+  ad=100p pd=50u as=100p ps=50u
M1149 a_523_21# b2_in vdd w_517_8# CMOSP w=20 l=2
+  ad=60p pd=26u as=100p ps=50u
M1150 p4_inv b4 a_960_167# w_883_182# CMOSP w=40 l=2
+  ad=0.2n pd=90u as=0.16n ps=48u
M1151 a_359_313# mid_s2 s2 Gnd CMOSN w=10 l=2
+  ad=50p pd=30u as=35p ps=17u
M1152 vdd g4_inv c5 w_908_310# CMOSP w=20 l=2
+  ad=100p pd=50u as=80p ps=28u
M1153 a_106_408# clk a_110_386# w_104_373# CMOSP w=20 l=2
+  ad=100p pd=50u as=60p ps=26u
M1154 a_106_502# a_107_477# vdd w_104_373# CMOSP w=20 l=2
+  ad=100p pd=50u as=100p ps=50u
M1155 a_519_43# clk a_523_21# w_517_8# CMOSP w=20 l=2
+  ad=100p pd=50u as=60p ps=26u
M1156 a_511_710# clk a_547_687# Gnd CMOSN w=20 l=2
+  ad=100p pd=50u as=70p ps=27u
M1157 a_512_685# a_512_660# vdd w_509_581# CMOSP w=20 l=2
+  ad=100p pd=50u as=100p ps=50u
M1158 a_182_44# b0_in gnd Gnd CMOSN w=20 l=2
+  ad=100p pd=50u as=100p ps=50u
M1159 a_687_112# clk a_722_89# Gnd CMOSN w=20 l=2
+  ad=100p pd=50u as=70p ps=27u
M1160 c4_in g4_inv vdd w_676_255# CMOSP w=20 l=2
+  ad=80p pd=28u as=100p ps=50u
M1161 a_7_414# a_6_396# vdd w_4_335# CMOSP w=20 l=2
+  ad=100p pd=50u as=100p ps=50u
M1162 a_334_218# a1 gnd Gnd CMOSN w=20 l=2
+  ad=80p pd=28u as=100p ps=50u
M1163 vdd a_441_300# p4 w_429_320# CMOSP w=20 l=2
+  ad=100p pd=50u as=100p ps=50u
M1164 temp107 a_538_529# gnd Gnd CMOSN w=10 l=2
+  ad=50p pd=30u as=50p ps=30u
M1165 a_384_90# a_349_88# gnd Gnd CMOSN w=20 l=2
+  ad=70p pd=27u as=100p ps=50u
M1166 b0 a0 mid_s0 w_63_186# CMOSP w=20 l=2
+  ad=100p pd=50u as=70p ps=27u
M1167 a_441_300# temp109 vdd w_429_320# CMOSP w=20 l=2
+  ad=80p pd=28u as=100p ps=50u
M1168 b4_inv b4 gnd Gnd CMOSN w=10 l=2
+  ad=50p pd=30u as=50p ps=30u
M1169 c4_inv c4_in vdd w_908_310# CMOSP w=20 l=2
+  ad=100p pd=50u as=100p ps=50u
M1170 gnd p2_inv a_538_529# Gnd CMOSN w=10 l=2
+  ad=50p pd=30u as=40p ps=18u
M1171 a_21_136# a_22_111# vdd w_19_7# CMOSP w=20 l=2
+  ad=100p pd=50u as=100p ps=50u
M1172 a_523_45# a_519_43# vdd w_517_8# CMOSP w=20 l=2
+  ad=60p pd=26u as=100p ps=50u
M1173 a_837_618# a_838_593# vdd w_835_489# CMOSP w=20 l=2
+  ad=100p pd=50u as=100p ps=50u
M1174 a_430_473# temp108 gnd Gnd CMOSN w=10 l=2
+  ad=40p pd=18u as=50p ps=30u
M1175 a_945_296# p4_inv vdd w_908_310# CMOSP w=40 l=2
+  ad=0.16n pd=48u as=0.2n ps=90u
M1176 s1 a_222_261# c1 Gnd CMOSN w=10 l=2
+  ad=35p pd=17u as=50p ps=30u
M1177 a_309_572# a_308_554# vdd w_306_493# CMOSP w=20 l=2
+  ad=100p pd=50u as=100p ps=50u
M1178 a_42_416# a_7_414# gnd Gnd CMOSN w=20 l=2
+  ad=70p pd=27u as=100p ps=50u
M1179 a_519_69# clk a_523_45# w_517_8# CMOSP w=20 l=2
+  ad=100p pd=50u as=60p ps=26u
M1180 s4_inv s4_out vdd w_740_467# CMOSP w=20 l=2
+  ad=100p pd=50u as=100p ps=50u
M1181 a_106_434# a_106_408# gnd Gnd CMOSN w=20 l=2
+  ad=100p pd=50u as=100p ps=50u
M1182 a_302_114# a_267_112# gnd Gnd CMOSN w=20 l=2
+  ad=70p pd=27u as=100p ps=50u
M1183 a_348_138# clk a_384_115# Gnd CMOSN w=20 l=2
+  ad=100p pd=50u as=70p ps=27u
M1184 gnd temp101 a_243_347# Gnd CMOSN w=20 l=2
+  ad=100p pd=50u as=80p ps=28u
M1185 gnd p2_inv temp105 Gnd CMOSN w=10 l=2
+  ad=50p pd=30u as=40p ps=18u
M1186 g0_inv a0 vdd w_63_186# CMOSP w=20 l=2
+  ad=80p pd=28u as=100p ps=50u
M1187 a_519_137# clk a_555_114# Gnd CMOSN w=20 l=2
+  ad=100p pd=50u as=70p ps=27u
M1188 temp112 g3_inv a_819_336# Gnd CMOSN w=20 l=2
+  ad=100p pd=50u as=80p ps=28u
M1189 a_654_579# clk a_690_556# Gnd CMOSN w=20 l=2
+  ad=100p pd=50u as=70p ps=27u
M1190 mid_s4 c4_in s4 w_837_269# CMOSP w=20 l=2
+  ad=100p pd=50u as=70p ps=27u
M1191 a_880_137# clk a_916_114# Gnd CMOSN w=20 l=2
+  ad=100p pd=50u as=70p ps=27u
M1192 s4 a_848_245# c4_in Gnd CMOSN w=10 l=2
+  ad=35p pd=17u as=50p ps=30u
M1193 a_743_546# a_742_528# vdd w_740_467# CMOSP w=20 l=2
+  ad=100p pd=50u as=100p ps=50u
M1194 a_515_594# s3 vdd w_509_581# CMOSP w=20 l=2
+  ad=60p pd=26u as=100p ps=50u
M1195 a_742_596# clk a_778_573# Gnd CMOSN w=20 l=2
+  ad=100p pd=50u as=70p ps=27u
M1196 a_183_88# a_182_70# vdd w_180_9# CMOSP w=20 l=2
+  ad=100p pd=50u as=100p ps=50u
M1197 c4_inv c4_out vdd w_652_450# CMOSP w=20 l=2
+  ad=100p pd=50u as=100p ps=50u
M1198 a_435_113# clk a_470_90# Gnd CMOSN w=20 l=2
+  ad=100p pd=50u as=70p ps=27u
M1199 temp108 g2_inv vdd w_419_492# CMOSP w=20 l=2
+  ad=80p pd=28u as=100p ps=50u
M1200 b1 a1 mid_s1 w_223_186# CMOSP w=20 l=2
+  ad=100p pd=50u as=70p ps=27u
M1201 a_837_550# a_837_524# gnd Gnd CMOSN w=20 l=2
+  ad=100p pd=50u as=100p ps=50u
M1202 c1 g0_inv a_174_260# Gnd CMOSN w=20 l=2
+  ad=100p pd=50u as=80p ps=28u
M1203 vdd temp107 temp108 w_419_492# CMOSP w=20 l=2
+  ad=100p pd=50u as=80p ps=28u
M1204 a_690_21# b3_in vdd w_684_8# CMOSP w=20 l=2
+  ad=60p pd=26u as=100p ps=50u
M1205 c2 a_379_391# vdd w_323_433# CMOSP w=20 l=2
+  ad=100p pd=50u as=100p ps=50u
M1206 a_511_710# a_512_685# vdd w_509_581# CMOSP w=20 l=2
+  ad=100p pd=50u as=100p ps=50u
M1207 a_22_111# clk a_57_88# Gnd CMOSN w=20 l=2
+  ad=100p pd=50u as=70p ps=27u
M1208 a_686_43# clk a_690_21# w_684_8# CMOSP w=20 l=2
+  ad=100p pd=50u as=60p ps=26u
M1209 a_125_272# c0_inv a_125_300# w_88_314# CMOSP w=40 l=2
+  ad=0.2n pd=90u as=0.16n ps=48u
M1210 temp110 a_694_386# vdd w_628_378# CMOSP w=20 l=2
+  ad=100p pd=50u as=100p ps=50u
M1211 c0 a_21_136# vdd w_19_7# CMOSP w=20 l=2
+  ad=100p pd=50u as=100p ps=50u
M1212 a_101_110# a_101_85# vdd w_98_6# CMOSP w=20 l=2
+  ad=100p pd=50u as=100p ps=50u
M1213 a_6_370# s0 gnd Gnd CMOSN w=20 l=2
+  ad=100p pd=50u as=100p ps=50u
M1214 a_42_441# a_7_439# gnd Gnd CMOSN w=20 l=2
+  ad=70p pd=27u as=100p ps=50u
M1215 s0 mid_s0 c0 w_17_273# CMOSP w=20 l=2
+  ad=70p pd=27u as=100p ps=50u
M1216 a_690_45# a_686_43# vdd w_684_8# CMOSP w=20 l=2
+  ad=60p pd=26u as=100p ps=50u
M1217 a_25_20# c0_in vdd w_19_7# CMOSP w=20 l=2
+  ad=60p pd=26u as=100p ps=50u
M1218 a_464_294# temp109 a_441_300# Gnd CMOSN w=20 l=2
+  ad=80p pd=28u as=100p ps=50u
M1219 a_308_528# s2 gnd Gnd CMOSN w=20 l=2
+  ad=100p pd=50u as=100p ps=50u
M1220 a_511_642# a_511_616# gnd Gnd CMOSN w=20 l=2
+  ad=100p pd=50u as=100p ps=50u
M1221 s1_out a_106_502# vdd w_104_373# CMOSP w=20 l=2
+  ad=100p pd=50u as=100p ps=50u
M1222 a_973_272# a_945_268# gnd Gnd CMOSN w=10 l=2
+  ad=50p pd=30u as=50p ps=30u
M1223 a_640_359# temp104 gnd Gnd CMOSN w=10 l=2
+  ad=40p pd=18u as=50p ps=30u
M1224 a_686_69# clk a_690_45# w_684_8# CMOSP w=20 l=2
+  ad=100p pd=50u as=60p ps=26u
M1225 a_348_44# b1_in gnd Gnd CMOSN w=20 l=2
+  ad=100p pd=50u as=100p ps=50u
M1226 a_348_138# a_349_113# vdd w_346_9# CMOSP w=20 l=2
+  ad=100p pd=50u as=100p ps=50u
M1227 b3 a_686_137# gnd Gnd CMOSN w=10 l=2
+  ad=50p pd=30u as=50p ps=30u
M1228 a_760_348# p3_inv gnd Gnd CMOSN w=10 l=2
+  ad=40p pd=18u as=50p ps=30u
M1229 a_21_42# clk a_25_20# w_19_7# CMOSP w=20 l=2
+  ad=100p pd=50u as=60p ps=26u
M1230 a_266_43# a1_in gnd Gnd CMOSN w=20 l=2
+  ad=100p pd=50u as=100p ps=50u
M1231 a_519_137# a_520_112# vdd w_517_8# CMOSP w=20 l=2
+  ad=100p pd=50u as=100p ps=50u
M1232 a_6_396# a_6_370# gnd Gnd CMOSN w=20 l=2
+  ad=100p pd=50u as=100p ps=50u
M1233 c5_out a_837_618# gnd Gnd CMOSN w=10 l=2
+  ad=50p pd=30u as=50p ps=30u
M1234 a_742_596# a_743_571# vdd w_740_467# CMOSP w=20 l=2
+  ad=100p pd=50u as=100p ps=50u
M1235 a_520_112# a_520_87# vdd w_517_8# CMOSP w=20 l=2
+  ad=100p pd=50u as=100p ps=50u
M1236 c1 temp100 vdd w_88_314# CMOSP w=20 l=2
+  ad=80p pd=28u as=100p ps=50u
M1237 c4_inv c4_in gnd Gnd CMOSN w=10 l=2
+  ad=50p pd=30u as=50p ps=30u
M1238 a_259_438# g0_inv vdd w_251_453# CMOSP w=40 l=2
+  ad=0.16n pd=48u as=0.2n ps=90u
M1239 a_125_272# p0_inv gnd Gnd CMOSN w=10 l=2
+  ad=40p pd=18u as=50p ps=30u
M1240 a_349_88# a_348_70# vdd w_346_9# CMOSP w=20 l=2
+  ad=100p pd=50u as=100p ps=50u
M1241 a_435_88# a_434_70# gnd Gnd CMOSN w=10 l=2
+  ad=50p pd=30u as=50p ps=30u
M1242 b2_inv a2 mid_s2 Gnd CMOSN w=10 l=2
+  ad=50p pd=30u as=35p ps=17u
M1243 a_658_463# c4_in vdd w_652_450# CMOSP w=20 l=2
+  ad=60p pd=26u as=100p ps=50u
M1244 a_25_44# a_21_42# vdd w_19_7# CMOSP w=20 l=2
+  ad=60p pd=26u as=100p ps=50u
M1245 a_881_112# clk a_916_89# Gnd CMOSN w=20 l=2
+  ad=100p pd=50u as=70p ps=27u
M1246 vdd temp101 a_220_353# w_208_373# CMOSP w=20 l=2
+  ad=100p pd=50u as=80p ps=28u
M1247 a_773_112# clk a_808_89# Gnd CMOSN w=20 l=2
+  ad=100p pd=50u as=70p ps=27u
M1248 vdd g3_inv temp112 w_806_368# CMOSP w=20 l=2
+  ad=100p pd=50u as=80p ps=28u
M1249 a_266_69# a_266_43# gnd Gnd CMOSN w=20 l=2
+  ad=100p pd=50u as=100p ps=50u
M1250 a_654_579# a_655_554# vdd w_652_450# CMOSP w=20 l=2
+  ad=100p pd=50u as=100p ps=50u
M1251 a_21_68# clk a_25_44# w_19_7# CMOSP w=20 l=2
+  ad=100p pd=50u as=60p ps=26u
M1252 gnd b4 p4_inv Gnd CMOSN w=10 l=2
+  ad=50p pd=30u as=40p ps=18u
M1253 a_493_482# g2_inv temp108 Gnd CMOSN w=20 l=2
+  ad=80p pd=28u as=100p ps=50u
M1254 a_359_313# c2 gnd Gnd CMOSN w=10 l=2
+  ad=50p pd=30u as=50p ps=30u
M1255 gnd temp107 a_493_482# Gnd CMOSN w=20 l=2
+  ad=100p pd=50u as=80p ps=28u
M1256 a_107_452# a_106_434# vdd w_104_373# CMOSP w=20 l=2
+  ad=100p pd=50u as=100p ps=50u
M1257 a_742_528# a_742_502# gnd Gnd CMOSN w=20 l=2
+  ad=100p pd=50u as=100p ps=50u
M1258 b3_inv a3 mid_s3 Gnd CMOSN w=10 l=2
+  ad=50p pd=30u as=35p ps=17u
M1259 temp103 a_231_438# vdd w_251_453# CMOSP w=20 l=2
+  ad=100p pd=50u as=100p ps=50u
M1260 a_873_570# a_838_568# gnd Gnd CMOSN w=20 l=2
+  ad=70p pd=27u as=100p ps=50u
M1261 a3 a_602_137# gnd Gnd CMOSN w=10 l=2
+  ad=50p pd=30u as=50p ps=30u
M1262 a_267_87# a_266_69# vdd w_264_8# CMOSP w=20 l=2
+  ad=100p pd=50u as=100p ps=50u
M1263 a_450_500# temp108 a_430_473# w_419_492# CMOSP w=40 l=2
+  ad=0.16n pd=48u as=0.2n ps=90u
M1264 gnd a_430_473# c3 Gnd CMOSN w=10 l=2
+  ad=50p pd=30u as=50p ps=30u
M1265 s0_out a_6_464# gnd Gnd CMOSN w=10 l=2
+  ad=50p pd=30u as=50p ps=30u
M1266 a_231_438# g0_inv gnd Gnd CMOSN w=10 l=2
+  ad=40p pd=18u as=50p ps=30u
M1267 b1 a_348_138# vdd w_346_9# CMOSP w=20 l=2
+  ad=100p pd=50u as=100p ps=50u
M1268 a_603_112# clk a_638_89# Gnd CMOSN w=20 l=2
+  ad=100p pd=50u as=70p ps=27u
M1269 b4_inv b4 vdd w_883_182# CMOSP w=20 l=2
+  ad=100p pd=50u as=100p ps=50u
M1270 s3_out a_511_710# vdd w_509_581# CMOSP w=20 l=2
+  ad=100p pd=50u as=100p ps=50u
M1271 a_101_85# a_100_67# gnd Gnd CMOSN w=10 l=2
+  ad=50p pd=30u as=50p ps=30u
M1272 vdd b1 g1_inv w_223_186# CMOSP w=20 l=2
+  ad=100p pd=50u as=80p ps=28u
M1273 a_973_272# a_945_268# vdd w_908_310# CMOSP w=20 l=2
+  ad=100p pd=50u as=100p ps=50u
M1274 a_266_137# a_267_112# vdd w_264_8# CMOSP w=20 l=2
+  ad=100p pd=50u as=100p ps=50u
M1275 b2 a_519_137# vdd w_517_8# CMOSP w=20 l=2
+  ad=100p pd=50u as=100p ps=50u
M1276 p2_inv b2 a_449_174# w_372_189# CMOSP w=40 l=2
+  ad=0.2n pd=90u as=0.16n ps=48u
M1277 a_183_113# clk a_218_90# Gnd CMOSN w=20 l=2
+  ad=100p pd=50u as=70p ps=27u
M1278 c2 a_379_391# gnd Gnd CMOSN w=10 l=2
+  ad=50p pd=30u as=50p ps=30u
M1279 a_960_167# a4 vdd w_883_182# CMOSP w=40 l=2
+  ad=0.16n pd=48u as=0.2n ps=90u
M1280 s4_out a_742_596# vdd w_740_467# CMOSP w=20 l=2
+  ad=100p pd=50u as=100p ps=50u
M1281 a_838_568# a_837_550# vdd w_835_489# CMOSP w=20 l=2
+  ad=100p pd=50u as=100p ps=50u
M1282 a_222_261# mid_s1 vdd w_211_285# CMOSP w=20 l=2
+  ad=100p pd=50u as=100p ps=50u
M1283 a_538_519# g1_inv vdd w_532_506# CMOSP w=40 l=2
+  ad=0.16n pd=48u as=0.2n ps=90u
M1284 s2_out a_308_622# gnd Gnd CMOSN w=10 l=2
+  ad=50p pd=30u as=50p ps=30u
M1285 vdd g1_inv temp104 w_323_433# CMOSP w=20 l=2
+  ad=100p pd=50u as=80p ps=28u
M1286 s0_inv s0_out gnd Gnd CMOSN w=10 l=2
+  ad=50p pd=30u as=50p ps=30u
M1287 a_884_21# b4_in vdd w_878_8# CMOSP w=20 l=2
+  ad=60p pd=26u as=100p ps=50u
M1288 b3_inv b3 vdd w_524_189# CMOSP w=20 l=2
+  ad=100p pd=50u as=100p ps=50u
M1289 a_687_112# a_687_87# vdd w_684_8# CMOSP w=20 l=2
+  ad=100p pd=50u as=100p ps=50u
M1290 a_776_21# a4_in vdd w_770_8# CMOSP w=20 l=2
+  ad=60p pd=26u as=100p ps=50u
M1291 a_28_249# c0 s0 Gnd CMOSN w=10 l=2
+  ad=50p pd=30u as=35p ps=17u
M1292 b0 a_182_138# gnd Gnd CMOSN w=10 l=2
+  ad=50p pd=30u as=50p ps=30u
M1293 a_880_43# clk a_884_21# w_878_8# CMOSP w=20 l=2
+  ad=100p pd=50u as=60p ps=26u
M1294 a_606_21# a3_in vdd w_600_8# CMOSP w=20 l=2
+  ad=60p pd=26u as=100p ps=50u
M1295 a_601_174# a3 vdd w_524_189# CMOSP w=40 l=2
+  ad=0.16n pd=48u as=0.2n ps=90u
M1296 p3_inv b3 a_601_174# w_524_189# CMOSP w=40 l=2
+  ad=0.2n pd=90u as=0.16n ps=48u
M1297 a_772_43# clk a_776_21# w_770_8# CMOSP w=20 l=2
+  ad=100p pd=50u as=60p ps=26u
M1298 c4_out a_654_579# vdd w_652_450# CMOSP w=20 l=2
+  ad=100p pd=50u as=100p ps=50u
M1299 a_602_43# clk a_606_21# w_600_8# CMOSP w=20 l=2
+  ad=100p pd=50u as=60p ps=26u
M1300 b0_inv b0 gnd Gnd CMOSN w=10 l=2
+  ad=50p pd=30u as=50p ps=30u
M1301 a_294_371# p1_inv temp101 w_281_365# CMOSP w=40 l=2
+  ad=0.16n pd=48u as=0.2n ps=90u
M1302 s2_inv s2_out gnd Gnd CMOSN w=10 l=2
+  ad=50p pd=30u as=50p ps=30u
M1303 mid_s0 b0_inv a0 Gnd CMOSN w=10 l=2
+  ad=35p pd=17u as=50p ps=30u
M1304 vdd p0_inv a_294_371# w_281_365# CMOSP w=40 l=2
+  ad=0.2n pd=90u as=0.16n ps=48u
M1305 a_7_414# a_6_396# gnd Gnd CMOSN w=10 l=2
+  ad=50p pd=30u as=50p ps=30u
M1306 a_359_313# c2 vdd w_348_337# CMOSP w=20 l=2
+  ad=100p pd=50u as=100p ps=50u
M1307 a_884_45# a_880_43# vdd w_878_8# CMOSP w=20 l=2
+  ad=60p pd=26u as=100p ps=50u
M1308 s3 c3 a_549_279# Gnd CMOSN w=10 l=2
+  ad=35p pd=17u as=50p ps=30u
M1309 a_512_660# a_511_642# vdd w_509_581# CMOSP w=20 l=2
+  ad=100p pd=50u as=100p ps=50u
M1310 a_434_138# clk a_470_115# Gnd CMOSN w=20 l=2
+  ad=100p pd=50u as=70p ps=27u
M1311 a_776_45# a_772_43# vdd w_770_8# CMOSP w=20 l=2
+  ad=60p pd=26u as=100p ps=50u
M1312 a_743_546# a_742_528# gnd Gnd CMOSN w=10 l=2
+  ad=50p pd=30u as=50p ps=30u
M1313 a_6_396# clk a_10_372# w_4_335# CMOSP w=20 l=2
+  ad=100p pd=50u as=60p ps=26u
M1314 a_22_111# a_22_86# vdd w_19_7# CMOSP w=20 l=2
+  ad=100p pd=50u as=100p ps=50u
M1315 a_880_69# clk a_884_45# w_878_8# CMOSP w=20 l=2
+  ad=100p pd=50u as=60p ps=26u
M1316 a_606_45# a_602_43# vdd w_600_8# CMOSP w=20 l=2
+  ad=60p pd=26u as=100p ps=50u
M1317 a_344_574# a_309_572# gnd Gnd CMOSN w=20 l=2
+  ad=70p pd=27u as=100p ps=50u
M1318 a_243_347# c0 a_220_353# Gnd CMOSN w=20 l=2
+  ad=80p pd=28u as=100p ps=50u
M1319 vdd temp109 a_660_386# w_628_378# CMOSP w=40 l=2
+  ad=0.2n pd=90u as=0.16n ps=48u
M1320 temp105 p1_inv gnd Gnd CMOSN w=10 l=2
+  ad=40p pd=18u as=50p ps=30u
M1321 vdd a_430_473# c3 w_419_492# CMOSP w=20 l=2
+  ad=100p pd=50u as=100p ps=50u
M1322 a_586_466# c1 a_586_428# Gnd CMOSN w=20 l=2
+  ad=100p pd=50u as=80p ps=28u
M1323 a_772_69# clk a_776_45# w_770_8# CMOSP w=20 l=2
+  ad=100p pd=50u as=60p ps=26u
M1324 a_309_572# a_308_554# gnd Gnd CMOSN w=10 l=2
+  ad=50p pd=30u as=50p ps=30u
M1325 a1 a_266_137# vdd w_264_8# CMOSP w=20 l=2
+  ad=100p pd=50u as=100p ps=50u
M1326 g2_inv b2 a_483_221# Gnd CMOSN w=20 l=2
+  ad=100p pd=50u as=80p ps=28u
M1327 a_760_348# g2_inv a_760_376# w_747_370# CMOSP w=40 l=2
+  ad=0.2n pd=90u as=0.16n ps=48u
M1328 a_312_530# a_308_528# vdd w_306_493# CMOSP w=20 l=2
+  ad=60p pd=26u as=100p ps=50u
M1329 a_302_89# a_267_87# gnd Gnd CMOSN w=20 l=2
+  ad=70p pd=27u as=100p ps=50u
M1330 a_819_336# temp111 gnd Gnd CMOSN w=20 l=2
+  ad=80p pd=28u as=100p ps=50u
M1331 a_602_69# clk a_606_45# w_600_8# CMOSP w=20 l=2
+  ad=100p pd=50u as=60p ps=26u
M1332 temp106 a_586_466# vdd w_573_460# CMOSP w=20 l=2
+  ad=100p pd=50u as=100p ps=50u
M1333 a_994_214# a4 gnd Gnd CMOSN w=20 l=2
+  ad=80p pd=28u as=100p ps=50u
M1334 a_182_44# clk a_186_22# w_180_9# CMOSP w=20 l=2
+  ad=100p pd=50u as=60p ps=26u
M1335 a_538_529# g1_inv gnd Gnd CMOSN w=10 l=2
+  ad=40p pd=18u as=50p ps=30u
M1336 mid_s1 c1 s1 w_211_285# CMOSP w=20 l=2
+  ad=100p pd=50u as=70p ps=27u
M1337 a_690_531# a_655_529# gnd Gnd CMOSN w=20 l=2
+  ad=70p pd=27u as=100p ps=50u
M1338 g0_inv b0 a_174_218# Gnd CMOSN w=20 l=2
+  ad=100p pd=50u as=80p ps=28u
M1339 a_308_554# clk a_312_530# w_306_493# CMOSP w=20 l=2
+  ad=100p pd=50u as=60p ps=26u
M1340 gnd a_220_353# temp102 Gnd CMOSN w=10 l=2
+  ad=50p pd=30u as=50p ps=30u
M1341 a_778_548# a_743_546# gnd Gnd CMOSN w=20 l=2
+  ad=70p pd=27u as=100p ps=50u
M1342 a_837_524# c5 gnd Gnd CMOSN w=20 l=2
+  ad=100p pd=50u as=100p ps=50u
M1343 temp103 a_231_438# gnd Gnd CMOSN w=10 l=2
+  ad=50p pd=30u as=50p ps=30u
M1344 a_174_260# temp100 gnd Gnd CMOSN w=20 l=2
+  ad=80p pd=28u as=100p ps=50u
M1345 c0 a_21_136# gnd Gnd CMOSN w=10 l=2
+  ad=50p pd=30u as=50p ps=30u
M1346 b2 a2 mid_s2 w_372_189# CMOSP w=20 l=2
+  ad=100p pd=50u as=70p ps=27u
M1347 a_435_88# a_434_70# vdd w_432_9# CMOSP w=20 l=2
+  ad=100p pd=50u as=100p ps=50u
M1348 a_722_114# a_687_112# gnd Gnd CMOSN w=20 l=2
+  ad=70p pd=27u as=100p ps=50u
M1349 mid_s1 b1_inv a1 Gnd CMOSN w=10 l=2
+  ad=35p pd=17u as=50p ps=30u
M1350 gnd c4_inv a_945_268# Gnd CMOSN w=10 l=2
+  ad=50p pd=30u as=40p ps=18u
M1351 c3 mid_s3 s3 w_543_295# CMOSP w=20 l=2
+  ad=100p pd=50u as=70p ps=27u
M1352 a_694_348# temp104 gnd Gnd CMOSN w=20 l=2
+  ad=80p pd=28u as=100p ps=50u
M1353 a_186_46# a_182_44# vdd w_180_9# CMOSP w=20 l=2
+  ad=60p pd=26u as=100p ps=50u
M1354 b4 a4 mid_s4 w_883_182# CMOSP w=20 l=2
+  ad=100p pd=50u as=70p ps=27u
M1355 a_100_135# a_101_110# vdd w_98_6# CMOSP w=20 l=2
+  ad=100p pd=50u as=100p ps=50u
M1356 g3_inv b3 a_635_221# Gnd CMOSN w=20 l=2
+  ad=100p pd=50u as=80p ps=28u
M1357 a_694_386# temp109 a_694_348# Gnd CMOSN w=20 l=2
+  ad=100p pd=50u as=80p ps=28u
M1358 a_125_300# p0_inv vdd w_88_314# CMOSP w=40 l=2
+  ad=0.16n pd=48u as=0.2n ps=90u
M1359 a_182_70# clk a_186_46# w_180_9# CMOSP w=20 l=2
+  ad=100p pd=50u as=60p ps=26u
M1360 a_349_113# clk a_384_90# Gnd CMOSN w=20 l=2
+  ad=100p pd=50u as=70p ps=27u
M1361 a_100_41# a0_in gnd Gnd CMOSN w=20 l=2
+  ad=100p pd=50u as=100p ps=50u
M1362 a_379_391# temp104 a_379_419# w_323_433# CMOSP w=40 l=2
+  ad=0.2n pd=90u as=0.16n ps=48u
M1363 b3 a3 mid_s3 w_524_189# CMOSP w=20 l=2
+  ad=100p pd=50u as=70p ps=27u
M1364 a_776_139# a_772_137# gnd Gnd CMOSN w=10 l=2
+  ad=50p pd=30u as=50p ps=30u
M1365 a_344_599# a_309_597# gnd Gnd CMOSN w=20 l=2
+  ad=70p pd=27u as=100p ps=50u
M1366 a_7_439# clk a_42_416# Gnd CMOSN w=20 l=2
+  ad=100p pd=50u as=70p ps=27u
M1367 a_655_529# a_654_511# vdd w_652_450# CMOSP w=20 l=2
+  ad=100p pd=50u as=100p ps=50u
M1368 a_101_85# a_100_67# vdd w_98_6# CMOSP w=20 l=2
+  ad=100p pd=50u as=100p ps=50u
M1369 temp100 a_125_272# gnd Gnd CMOSN w=10 l=2
+  ad=50p pd=30u as=50p ps=30u
M1370 a_266_137# clk a_302_114# Gnd CMOSN w=20 l=2
+  ad=100p pd=50u as=70p ps=27u
M1371 a_742_502# s4 gnd Gnd CMOSN w=20 l=2
+  ad=100p pd=50u as=100p ps=50u
M1372 s1_out a_106_502# gnd Gnd CMOSN w=10 l=2
+  ad=50p pd=30u as=50p ps=30u
M1373 g4_inv b4 a_994_214# Gnd CMOSN w=20 l=2
+  ad=100p pd=50u as=80p ps=28u
M1374 a_100_67# a_100_41# gnd Gnd CMOSN w=20 l=2
+  ad=100p pd=50u as=100p ps=50u
M1375 s2 a_359_313# mid_s2 Gnd CMOSN w=10 l=2
+  ad=35p pd=17u as=50p ps=30u
M1376 c2 mid_s2 s2 w_348_337# CMOSP w=20 l=2
+  ad=100p pd=50u as=70p ps=27u
M1377 a_348_44# clk a_352_22# w_346_9# CMOSP w=20 l=2
+  ad=100p pd=50u as=60p ps=26u
M1378 a_519_43# b2_in gnd Gnd CMOSN w=20 l=2
+  ad=100p pd=50u as=100p ps=50u
M1379 a_434_138# a_435_113# vdd w_432_9# CMOSP w=20 l=2
+  ad=100p pd=50u as=100p ps=50u
M1380 a_881_112# a_881_87# vdd w_878_8# CMOSP w=20 l=2
+  ad=100p pd=50u as=100p ps=50u
M1381 a_22_86# a_21_68# gnd Gnd CMOSN w=10 l=2
+  ad=50p pd=30u as=50p ps=30u
M1382 temp104 g1_inv a_336_401# Gnd CMOSN w=20 l=2
+  ad=100p pd=50u as=80p ps=28u
M1383 vdd a_220_353# temp102 w_208_373# CMOSP w=20 l=2
+  ad=100p pd=50u as=100p ps=50u
M1384 a_773_112# a_773_87# vdd w_770_8# CMOSP w=20 l=2
+  ad=100p pd=50u as=100p ps=50u
M1385 a_220_353# c0 vdd w_208_373# CMOSP w=20 l=2
+  ad=80p pd=28u as=100p ps=50u
M1386 vdd c1 a_586_466# w_573_460# CMOSP w=20 l=2
+  ad=100p pd=50u as=80p ps=28u
M1387 a_603_112# a_603_87# vdd w_600_8# CMOSP w=20 l=2
+  ad=100p pd=50u as=100p ps=50u
M1388 a0 a_100_135# vdd w_98_6# CMOSP w=20 l=2
+  ad=100p pd=50u as=100p ps=50u
M1389 temp112 temp111 vdd w_806_368# CMOSP w=20 l=2
+  ad=80p pd=28u as=100p ps=50u
M1390 a_654_511# a_654_485# gnd Gnd CMOSN w=20 l=2
+  ad=100p pd=50u as=100p ps=50u
M1391 gnd b2 p2_inv Gnd CMOSN w=10 l=2
+  ad=50p pd=30u as=40p ps=18u
M1392 s1_inv s1_out gnd Gnd CMOSN w=10 l=2
+  ad=50p pd=30u as=50p ps=30u
M1393 b1_inv b1 gnd Gnd CMOSN w=10 l=2
+  ad=50p pd=30u as=50p ps=30u
M1394 a_352_46# a_348_44# vdd w_346_9# CMOSP w=20 l=2
+  ad=60p pd=26u as=100p ps=50u
M1395 a_520_87# a_519_69# vdd w_517_8# CMOSP w=20 l=2
+  ad=100p pd=50u as=100p ps=50u
M1396 p4_inv a4 gnd Gnd CMOSN w=10 l=2
+  ad=40p pd=18u as=50p ps=30u
M1397 mid_s0 b0 a0 w_63_186# CMOSP w=20 l=2
+  ad=70p pd=27u as=100p ps=50u
M1398 temp107 a_538_529# vdd w_532_506# CMOSP w=20 l=2
+  ad=100p pd=50u as=100p ps=50u
M1399 a_638_114# a_603_112# gnd Gnd CMOSN w=20 l=2
+  ad=70p pd=27u as=100p ps=50u
M1400 gnd b0 p0_inv Gnd CMOSN w=10 l=2
+  ad=50p pd=30u as=40p ps=18u
M1401 a_348_70# clk a_352_46# w_346_9# CMOSP w=20 l=2
+  ad=100p pd=50u as=60p ps=26u
M1402 a_519_69# a_519_43# gnd Gnd CMOSN w=20 l=2
+  ad=100p pd=50u as=100p ps=50u
M1403 a_349_88# a_348_70# gnd Gnd CMOSN w=10 l=2
+  ad=50p pd=30u as=50p ps=30u
M1404 s3_out a_511_710# gnd Gnd CMOSN w=10 l=2
+  ad=50p pd=30u as=50p ps=30u
M1405 temp113 c0 a_689_223# Gnd CMOSN w=20 l=2
+  ad=100p pd=50u as=80p ps=28u
M1406 a_267_87# a_266_69# gnd Gnd CMOSN w=10 l=2
+  ad=50p pd=30u as=50p ps=30u
M1407 b4 a_880_137# gnd Gnd CMOSN w=10 l=2
+  ad=50p pd=30u as=50p ps=30u
M1408 a_28_249# mid_s0 gnd Gnd CMOSN w=10 l=2
+  ad=50p pd=30u as=50p ps=30u
M1409 a_694_386# temp104 vdd w_628_378# CMOSP w=20 l=2
+  ad=80p pd=28u as=100p ps=50u
M1410 a_142_454# a_107_452# gnd Gnd CMOSN w=20 l=2
+  ad=70p pd=27u as=100p ps=50u
M1411 b2_inv b2 vdd w_372_189# CMOSP w=20 l=2
+  ad=100p pd=50u as=100p ps=50u
M1412 vdd temp109 a_694_386# w_628_378# CMOSP w=20 l=2
+  ad=100p pd=50u as=80p ps=28u
M1413 s4_out a_742_596# gnd Gnd CMOSN w=10 l=2
+  ad=50p pd=30u as=50p ps=30u
M1414 a_6_464# clk a_42_441# Gnd CMOSN w=20 l=2
+  ad=100p pd=50u as=70p ps=27u
M1415 p3_inv a3 gnd Gnd CMOSN w=10 l=2
+  ad=40p pd=18u as=50p ps=30u
M1416 c5_inv c5_out gnd Gnd CMOSN w=10 l=2
+  ad=50p pd=30u as=50p ps=30u
M1417 a_107_452# a_106_434# gnd Gnd CMOSN w=10 l=2
+  ad=50p pd=30u as=50p ps=30u
M1418 a_7_439# a_7_414# vdd w_4_335# CMOSP w=20 l=2
+  ad=100p pd=50u as=100p ps=50u
M1419 a_686_43# b3_in gnd Gnd CMOSN w=20 l=2
+  ad=100p pd=50u as=100p ps=50u
M1420 b4_inv a4 mid_s4 Gnd CMOSN w=10 l=2
+  ad=50p pd=30u as=35p ps=17u
M1421 gnd b3 p3_inv Gnd CMOSN w=10 l=2
+  ad=50p pd=30u as=40p ps=18u
M1422 a_110_410# a_106_408# vdd w_104_373# CMOSP w=20 l=2
+  ad=60p pd=26u as=100p ps=50u
M1423 a_183_113# a_183_88# vdd w_180_9# CMOSP w=20 l=2
+  ad=100p pd=50u as=100p ps=50u
M1424 temp105 p2_inv a_535_452# w_522_446# CMOSP w=40 l=2
+  ad=0.2n pd=90u as=0.16n ps=48u
M1425 g1_inv a1 vdd w_223_186# CMOSP w=20 l=2
+  ad=80p pd=28u as=100p ps=50u
M1426 gnd temp104 a_379_391# Gnd CMOSN w=10 l=2
+  ad=50p pd=30u as=40p ps=18u
M1427 a_449_174# a2 vdd w_372_189# CMOSP w=40 l=2
+  ad=0.16n pd=48u as=0.2n ps=90u
M1428 a_837_524# clk a_841_502# w_835_489# CMOSP w=20 l=2
+  ad=100p pd=50u as=60p ps=26u
M1429 vdd b2 g2_inv w_372_189# CMOSP w=20 l=2
+  ad=100p pd=50u as=80p ps=28u
M1430 temp100 a_125_272# vdd w_88_314# CMOSP w=20 l=2
+  ad=100p pd=50u as=100p ps=50u
M1431 a_106_434# clk a_110_410# w_104_373# CMOSP w=20 l=2
+  ad=100p pd=50u as=60p ps=26u
M1432 b1 a_348_138# gnd Gnd CMOSN w=10 l=2
+  ad=50p pd=30u as=50p ps=30u
M1433 g4_inv a4 vdd w_883_182# CMOSP w=20 l=2
+  ad=80p pd=28u as=100p ps=50u
M1434 s4 mid_s4 c4_in w_837_269# CMOSP w=20 l=2
+  ad=70p pd=27u as=100p ps=50u
M1435 temp104 temp103 vdd w_323_433# CMOSP w=20 l=2
+  ad=80p pd=28u as=100p ps=50u
M1436 a_881_87# a_880_69# gnd Gnd CMOSN w=10 l=2
+  ad=50p pd=30u as=50p ps=30u
M1437 a_218_115# a_183_113# gnd Gnd CMOSN w=20 l=2
+  ad=70p pd=27u as=100p ps=50u
M1438 a_308_622# clk a_344_599# Gnd CMOSN w=20 l=2
+  ad=100p pd=50u as=70p ps=27u
M1439 b2 a_519_137# gnd Gnd CMOSN w=10 l=2
+  ad=50p pd=30u as=50p ps=30u
M1440 a2 a_434_138# vdd w_432_9# CMOSP w=20 l=2
+  ad=100p pd=50u as=100p ps=50u
M1441 c4_out a_654_579# gnd Gnd CMOSN w=10 l=2
+  ad=50p pd=30u as=50p ps=30u
M1442 a_773_87# a_772_69# gnd Gnd CMOSN w=10 l=2
+  ad=50p pd=30u as=50p ps=30u
M1443 mid_s1 b1 a1 w_223_186# CMOSP w=20 l=2
+  ad=70p pd=27u as=100p ps=50u
M1444 a_838_568# a_837_550# gnd Gnd CMOSN w=10 l=2
+  ad=50p pd=30u as=50p ps=30u
M1445 a_841_526# a_837_524# vdd w_835_489# CMOSP w=20 l=2
+  ad=60p pd=26u as=100p ps=50u
M1446 a_686_69# a_686_43# gnd Gnd CMOSN w=20 l=2
+  ad=100p pd=50u as=100p ps=50u
M1447 a_686_137# a_687_112# vdd w_684_8# CMOSP w=20 l=2
+  ad=100p pd=50u as=100p ps=50u
M1448 mid_s4 b4 a4 w_883_182# CMOSP w=20 l=2
+  ad=70p pd=27u as=100p ps=50u
M1449 vdd b3 g3_inv w_524_189# CMOSP w=20 l=2
+  ad=100p pd=50u as=80p ps=28u
M1450 c0_inv c0 gnd Gnd CMOSN w=10 l=2
+  ad=50p pd=30u as=50p ps=30u
M1451 a_512_660# a_511_642# gnd Gnd CMOSN w=10 l=2
+  ad=50p pd=30u as=50p ps=30u
M1452 a_837_550# clk a_841_526# w_835_489# CMOSP w=20 l=2
+  ad=100p pd=50u as=60p ps=26u
M1453 s3_inv s3_out gnd Gnd CMOSN w=10 l=2
+  ad=50p pd=30u as=50p ps=30u
M1454 a_106_408# s1 gnd Gnd CMOSN w=20 l=2
+  ad=100p pd=50u as=100p ps=50u
M1455 p0_inv b0 a_140_171# w_63_186# CMOSP w=40 l=2
+  ad=0.2n pd=90u as=0.16n ps=48u
M1456 a_136_87# a_101_85# gnd Gnd CMOSN w=20 l=2
+  ad=70p pd=27u as=100p ps=50u
M1457 a_10_348# s0 vdd w_4_335# CMOSP w=20 l=2
+  ad=60p pd=26u as=100p ps=50u
M1458 a_687_87# a_686_69# vdd w_684_8# CMOSP w=20 l=2
+  ad=100p pd=50u as=100p ps=50u
M1459 vdd temp112 a_734_309# w_728_296# CMOSP w=40 l=2
+  ad=0.2n pd=90u as=0.16n ps=48u
M1460 a_142_479# a_107_477# gnd Gnd CMOSN w=20 l=2
+  ad=70p pd=27u as=100p ps=50u
M1461 a_603_87# a_602_69# gnd Gnd CMOSN w=10 l=2
+  ad=50p pd=30u as=50p ps=30u
M1462 a_6_370# clk a_10_348# w_4_335# CMOSP w=20 l=2
+  ad=100p pd=50u as=60p ps=26u
M1463 a_6_464# a_7_439# vdd w_4_335# CMOSP w=20 l=2
+  ad=100p pd=50u as=100p ps=50u
M1464 a_547_662# a_512_660# gnd Gnd CMOSN w=20 l=2
+  ad=70p pd=27u as=100p ps=50u
M1465 a_838_593# clk a_873_570# Gnd CMOSN w=20 l=2
+  ad=100p pd=50u as=70p ps=27u
M1466 a_28_249# mid_s0 vdd w_17_273# CMOSP w=20 l=2
+  ad=100p pd=50u as=100p ps=50u
M1467 a_660_386# temp104 a_640_359# w_628_378# CMOSP w=40 l=2
+  ad=0.16n pd=48u as=0.2n ps=90u
M1468 a_586_428# temp105 gnd Gnd CMOSN w=20 l=2
+  ad=80p pd=28u as=100p ps=50u
M1469 a_21_42# c0_in gnd Gnd CMOSN w=20 l=2
+  ad=100p pd=50u as=100p ps=50u
M1470 a_483_221# a2 gnd Gnd CMOSN w=20 l=2
+  ad=80p pd=28u as=100p ps=50u
M1471 a_760_376# p3_inv vdd w_747_370# CMOSP w=40 l=2
+  ad=0.16n pd=48u as=0.2n ps=90u
M1472 a_515_618# a_511_616# vdd w_509_581# CMOSP w=20 l=2
+  ad=60p pd=26u as=100p ps=50u
M1473 a_312_506# s2 vdd w_306_493# CMOSP w=20 l=2
+  ad=60p pd=26u as=100p ps=50u
M1474 a_349_113# a_349_88# vdd w_346_9# CMOSP w=20 l=2
+  ad=100p pd=50u as=100p ps=50u
M1475 a_57_113# a_22_111# gnd Gnd CMOSN w=20 l=2
+  ad=70p pd=27u as=100p ps=50u
M1476 vdd b4 g4_inv w_883_182# CMOSP w=20 l=2
+  ad=100p pd=50u as=80p ps=28u
M1477 a_174_218# a0 gnd Gnd CMOSN w=20 l=2
+  ad=80p pd=28u as=100p ps=50u
M1478 a_511_642# clk a_515_618# w_509_581# CMOSP w=20 l=2
+  ad=100p pd=50u as=60p ps=26u
M1479 a_308_528# clk a_312_506# w_306_493# CMOSP w=20 l=2
+  ad=100p pd=50u as=60p ps=26u
M1480 vdd c0 temp113 w_676_255# CMOSP w=20 l=2
+  ad=100p pd=50u as=80p ps=28u
M1481 a_10_372# a_6_370# vdd w_4_335# CMOSP w=20 l=2
+  ad=60p pd=26u as=100p ps=50u
M1482 a_873_595# a_838_593# gnd Gnd CMOSN w=20 l=2
+  ad=70p pd=27u as=100p ps=50u
M1483 a_434_70# a_434_44# gnd Gnd CMOSN w=20 l=2
+  ad=100p pd=50u as=100p ps=50u
M1484 a_555_89# a_520_87# gnd Gnd CMOSN w=20 l=2
+  ad=70p pd=27u as=100p ps=50u
M1485 a_434_44# clk a_438_22# w_432_9# CMOSP w=20 l=2
+  ad=100p pd=50u as=60p ps=26u
M1486 c4_inv c4_out gnd Gnd CMOSN w=10 l=2
+  ad=50p pd=30u as=50p ps=30u
M1487 a_22_86# a_21_68# vdd w_19_7# CMOSP w=20 l=2
+  ad=100p pd=50u as=100p ps=50u
M1488 a_222_261# c1 s1 Gnd CMOSN w=10 l=2
+  ad=50p pd=30u as=35p ps=17u
M1489 s4_inv s4_out gnd Gnd CMOSN w=10 l=2
+  ad=50p pd=30u as=50p ps=30u
M1490 mid_s2 b2_inv a2 Gnd CMOSN w=10 l=2
+  ad=35p pd=17u as=50p ps=30u
M1491 b3 a_686_137# vdd w_684_8# CMOSP w=20 l=2
+  ad=100p pd=50u as=100p ps=50u
M1492 a_945_268# p4_inv gnd Gnd CMOSN w=10 l=2
+  ad=40p pd=18u as=50p ps=30u
M1493 a_186_22# b0_in vdd w_180_9# CMOSP w=20 l=2
+  ad=60p pd=26u as=100p ps=50u
M1494 a_635_221# a3 gnd Gnd CMOSN w=20 l=2
+  ad=80p pd=28u as=100p ps=50u
M1495 a_21_68# a_21_42# gnd Gnd CMOSN w=20 l=2
+  ad=100p pd=50u as=100p ps=50u
M1496 temp109 p3_inv gnd Gnd CMOSN w=10 l=2
+  ad=40p pd=18u as=50p ps=30u
M1497 a_512_685# clk a_547_662# Gnd CMOSN w=20 l=2
+  ad=100p pd=50u as=70p ps=27u
M1498 a_438_46# a_434_44# vdd w_432_9# CMOSP w=20 l=2
+  ad=60p pd=26u as=100p ps=50u
M1499 gnd p2_inv temp109 Gnd CMOSN w=10 l=2
+  ad=50p pd=30u as=40p ps=18u
M1500 gnd a_640_359# temp110 Gnd CMOSN w=10 l=2
+  ad=50p pd=30u as=50p ps=30u
M1501 a_808_114# a_773_112# gnd Gnd CMOSN w=20 l=2
+  ad=70p pd=27u as=100p ps=50u
M1502 a_511_616# s3 gnd Gnd CMOSN w=20 l=2
+  ad=100p pd=50u as=100p ps=50u
M1503 c4_in temp113 a_723_223# Gnd CMOSN w=20 l=2
+  ad=100p pd=50u as=80p ps=28u
M1504 a_848_245# c4_in s4 Gnd CMOSN w=10 l=2
+  ad=50p pd=30u as=35p ps=17u
M1505 gnd temp112 g4_inv Gnd CMOSN w=10 l=2
+  ad=50p pd=30u as=40p ps=18u
M1506 a_379_419# temp102 vdd w_323_433# CMOSP w=40 l=2
+  ad=0.16n pd=48u as=0.2n ps=90u
M1507 a_655_529# a_654_511# gnd Gnd CMOSN w=10 l=2
+  ad=50p pd=30u as=50p ps=30u
M1508 a_434_70# clk a_438_46# w_432_9# CMOSP w=20 l=2
+  ad=100p pd=50u as=60p ps=26u
M1509 mid_s3 b3_inv a3 Gnd CMOSN w=10 l=2
+  ad=35p pd=17u as=50p ps=30u
M1510 a_746_504# a_742_502# vdd w_740_467# CMOSP w=20 l=2
+  ad=60p pd=26u as=100p ps=50u
M1511 a_880_43# b4_in gnd Gnd CMOSN w=20 l=2
+  ad=100p pd=50u as=100p ps=50u
M1512 a_547_687# a_512_685# gnd Gnd CMOSN w=20 l=2
+  ad=70p pd=27u as=100p ps=50u
M1513 a_838_593# a_838_568# vdd w_835_489# CMOSP w=20 l=2
+  ad=100p pd=50u as=100p ps=50u
M1514 a_722_89# a_687_87# gnd Gnd CMOSN w=20 l=2
+  ad=70p pd=27u as=100p ps=50u
M1515 a_772_43# a4_in gnd Gnd CMOSN w=20 l=2
+  ad=100p pd=50u as=100p ps=50u
M1516 mid_s4 b4_inv a4 Gnd CMOSN w=10 l=2
+  ad=35p pd=17u as=50p ps=30u
M1517 a_742_528# clk a_746_504# w_740_467# CMOSP w=20 l=2
+  ad=100p pd=50u as=60p ps=26u
M1518 a_309_597# clk a_344_574# Gnd CMOSN w=20 l=2
+  ad=100p pd=50u as=70p ps=27u
M1519 a_267_112# clk a_302_89# Gnd CMOSN w=20 l=2
+  ad=100p pd=50u as=70p ps=27u
M1520 a0 a_100_135# gnd Gnd CMOSN w=10 l=2
+  ad=50p pd=30u as=50p ps=30u
M1521 temp111 a_760_348# gnd Gnd CMOSN w=10 l=2
+  ad=50p pd=30u as=50p ps=30u
C0 vdd a_267_87# 0.0012f
C1 gnd a_101_85# 0.00473f
C2 g2_inv p3_inv 0.21121f
C3 s2 c2 0.00216f
C4 c0 w_88_314# 0.02544f
C5 a_586_466# vdd 0.00106f
C6 a_511_616# vdd 0.00148f
C7 s4_out gnd 0.01932f
C8 b0 vdd 0.07552f
C9 a0 gnd 0.02158f
C10 p1_inv vdd 0.07895f
C11 c5 gnd 0.00162f
C12 a_603_87# a_602_69# 0.05922f
C13 vdd b2_in 0.00151f
C14 s4 w_740_467# 0.02042f
C15 temp104 temp109 0.35954f
C16 c1 mid_s1 0.07768f
C17 p3_inv a_760_348# 0.02579f
C18 gnd a_57_88# 0
C19 vdd a_22_86# 0.0012f
C20 s3 w_522_446# 0
C21 vdd w_372_189# 0.05711f
C22 clk a_881_112# 0.03055f
C23 a_294_371# vdd 0
C24 a_6_370# gnd 0.00167f
C25 c4_in a_848_245# 0.02788f
C26 w_432_9# a_435_113# 0.03401f
C27 a_512_660# clk 0.02938f
C28 s2_inv gnd 0
C29 s2_out vdd 0.00149f
C30 temp113 gnd 0.00109f
C31 a_848_245# vdd 0
C32 b3 a_635_221# 0
C33 a_434_44# a2_in 0.03186f
C34 w_19_7# c0 0.01464f
C35 a_654_511# clk 0.00836f
C36 a_742_502# vdd 0.00148f
C37 vdd a1_in 0.00151f
C38 gnd a0_in 0.00153f
C39 c1 w_573_460# 0.02076f
C40 p3_inv a_694_386# 0.00453f
C41 c5_out w_835_489# 0.02904f
C42 vdd w_429_320# 0.02766f
C43 gnd a_722_114# 0
C44 a_106_408# vdd 0.00148f
C45 p0_inv gnd 0.20114f
C46 mid_s2 a2 0.26686f
C47 p1_inv w_323_433# 0.03083f
C48 s2 w_306_493# 0.02042f
C49 s3_inv vdd 0
C50 w_770_8# clk 0.05738f
C51 a_106_502# w_104_373# 0.03596f
C52 b2 a_449_174# 0
C53 mid_s3 vdd 0.0569f
C54 c4_inv gnd 0.0015f
C55 a_655_529# gnd 0.00473f
C56 a_430_473# g1_inv 0.00213f
C57 p2_inv vdd 0.07377f
C58 vdd c0_in 0.00156f
C59 clk a_880_43# 0.08021f
C60 c1 mid_s2 0.00373f
C61 w_432_9# a_434_44# 0.02662f
C62 gnd a_384_115# 0
C63 temp110 g4_inv 0.11558f
C64 w_98_6# clk 0.05761f
C65 w_770_8# a_776_139# 0.00802f
C66 w_264_8# vdd 0.0391f
C67 w_600_8# a_602_137# 0.03596f
C68 b1 a_300_171# 0
C69 a2 b2 0.63166f
C70 a_22_86# a_21_68# 0.05922f
C71 vdd a_776_45# 0
C72 a_231_438# g0_inv 0.02579f
C73 c4_in clk 0.07422f
C74 temp110 w_728_296# 0.02017f
C75 a_512_685# w_509_581# 0.03401f
C76 vdd clk 2.99824f
C77 s3 c1 0.00472f
C78 temp110 a_734_309# 0
C79 s4_out a_742_596# 0.05934f
C80 a_308_554# w_306_493# 0.0271f
C81 b0 a_140_171# 0
C82 b1_inv b1 0.06519f
C83 a_880_69# a_880_43# 0.03186f
C84 p1_inv temp102 0.00545f
C85 temp103 a_231_438# 0.04402f
C86 vdd a_438_46# 0
C87 mid_s1 vdd 0.18094f
C88 temp100 gnd 0.00163f
C89 c3 p4 0
C90 mid_s2 w_348_337# 0.0248f
C91 temp105 a_586_466# 0.00105f
C92 a_430_473# c3 0.04426f
C93 s1_out vdd 0.00149f
C94 a_308_528# gnd 0.00167f
C95 a_434_138# gnd 0.0011f
C96 a_776_139# vdd 0
C97 a_348_138# clk 0.00117f
C98 c0 a3 0.01884f
C99 s4_inv s4_out 0.04402f
C100 p1_inv temp105 0.02579f
C101 temp102 a_294_371# 0.00254f
C102 b0_inv a0 0.03149f
C103 mid_s3 b3 0.00216f
C104 a_519_69# a_519_43# 0.03186f
C105 a_106_434# w_104_373# 0.0271f
C106 vdd a_880_69# 0.00148f
C107 clk a_686_69# 0.00836f
C108 gnd a_772_69# 0.00145f
C109 vdd w_573_460# 0.02114f
C110 temp109 gnd 0.04528f
C111 gnd w_522_446# 0
C112 temp101 vdd 0.00294f
C113 p3_inv w_628_378# 0.04623f
C114 w_600_8# a_603_87# 0.02689f
C115 a_837_550# gnd 0.00145f
C116 a_538_529# vdd 0
C117 w_180_9# a_182_70# 0.0271f
C118 w_98_6# a_100_67# 0.0271f
C119 b2_inv w_372_189# 0.00602f
C120 c0 b1 0.01065f
C121 a_945_268# a_973_272# 0.04402f
C122 temp110 temp112 0.22858f
C123 gnd a_182_70# 0.00145f
C124 vdd a_100_67# 0.00148f
C125 g1_inv p1_inv 0.54755f
C126 s0_inv s0_out 0.04402f
C127 clk a_21_68# 0.00836f
C128 a_243_347# gnd 0
C129 s0 clk 0.07184f
C130 p0_inv c1 0.00121f
C131 temp108 g2_inv 0.0503f
C132 a_743_571# gnd 0.00483f
C133 temp113 w_676_255# 0.03349f
C134 mid_s4 w_837_269# 0.08752f
C135 p0_inv b0_inv 0.00746f
C136 a_7_414# clk 0.02938f
C137 w_524_189# a3 0.08036f
C138 w_346_9# b1 0.00793f
C139 p2_inv temp105 0.11558f
C140 w_600_8# a3_in 0.0205f
C141 temp106 w_419_492# 0.0188f
C142 gnd a_808_89# 0
C143 temp104 vdd 0.00309f
C144 a_586_428# gnd 0
C145 g2_inv temp110 0.0051f
C146 a_106_408# s1 0.04857f
C147 w_878_8# a_881_112# 0.03401f
C148 w_98_6# a_101_85# 0.02689f
C149 a_742_596# gnd 0.0011f
C150 s3 vdd 0.0042f
C151 b4 a_994_214# 0
C152 b2 vdd 0.16277f
C153 a2 gnd 0.02239f
C154 a4 a_960_167# 0.00256f
C155 a_107_452# gnd 0.00473f
C156 w_98_6# a0 0.02402f
C157 a_655_529# a_654_511# 0.05922f
C158 gnd a_470_90# 0
C159 p2_inv g1_inv 0.17768f
C160 vdd a_101_85# 0.0012f
C161 c1 gnd 0.00937f
C162 a_658_487# vdd 0
C163 w_19_7# a_22_86# 0.02689f
C164 s4_out vdd 0.00149f
C165 w_517_8# a_520_112# 0.03401f
C166 c5 c4_in 0.00172f
C167 s4_inv gnd 0
C168 a0 vdd 0.01449f
C169 b0_inv gnd 0.11731f
C170 a2 a_434_138# 0.05946f
C171 a_493_482# gnd 0
C172 a_107_477# clk 0.03055f
C173 s2 temp103 0
C174 c3 p1_inv 0.01271f
C175 c5 vdd 1.33849f
C176 vdd a_884_21# 0
C177 p4_inv c4_inv 0.19352f
C178 c4_in w_837_269# 0.0302f
C179 temp104 w_323_433# 0.04473f
C180 c1 temp100 0.00105f
C181 a_694_386# temp110 0.04547f
C182 w_98_6# a0_in 0.0205f
C183 w_878_8# a_880_43# 0.02662f
C184 clk a_773_112# 0.03055f
C185 vdd w_837_269# 0.00794f
C186 gnd a_881_112# 0.00483f
C187 c4_in temp113 0.05029f
C188 s1 clk 0.07675f
C189 a_6_370# vdd 0.00148f
C190 s3 g3_inv 0
C191 s2_inv vdd 0
C192 a_512_660# gnd 0.00473f
C193 temp102 temp101 0.00233f
C194 temp113 vdd 0.00186f
C195 mid_s4 gnd 0.18444f
C196 a_746_504# vdd 0
C197 a_654_511# gnd 0.00145f
C198 a_435_88# a_434_70# 0.05922f
C199 vdd a0_in 0.00154f
C200 temp105 w_573_460# 0.02095f
C201 s1 mid_s1 0.00216f
C202 w_517_8# a_519_43# 0.02662f
C203 w_19_7# c0_in 0.0205f
C204 gnd a_638_114# 0
C205 vdd w_806_368# 0.01452f
C206 p0_inv vdd 0.0169f
C207 c4_in c4_inv 0.04402f
C208 p1_inv w_251_453# 0.0225f
C209 w_684_8# clk 0.05738f
C210 a_655_529# c4_in 0
C211 c3 mid_s3 0.0804f
C212 w_878_8# vdd 0.03931f
C213 a2 a_449_174# 0.00256f
C214 p4_inv gnd 0.07573f
C215 b2 b3 0.00505f
C216 c4_inv vdd 0
C217 c3 p2_inv 0.02866f
C218 a_655_529# vdd 0.0012f
C219 a_690_531# gnd 0
C220 clk a_772_43# 0.08021f
C221 vdd a_25_20# 0
C222 gnd a_880_43# 0.00167f
C223 a_28_249# w_17_273# 0.00598f
C224 c0 a_28_249# 0.02788f
C225 p0_inv a_125_272# 0.02579f
C226 clk a_183_113# 0.03055f
C227 gnd a_302_114# 0
C228 g2_inv c0 0.02444f
C229 mid_s2 b2_inv 0
C230 w_19_7# clk 0.04117f
C231 temp102 temp104 0.18136f
C232 w_180_9# vdd 0.0391f
C233 a1 a_300_171# 0.00256f
C234 b1 a_334_218# 0
C235 a_538_529# g1_inv 0.02579f
C236 g0_inv a_174_218# 0.00255f
C237 vdd a_690_45# 0
C238 c4_in gnd 0.58431f
C239 g3_inv w_806_368# 0.02076f
C240 a_6_370# s0 0.03186f
C241 c1 a_586_428# 0
C242 w_770_8# a_772_69# 0.0271f
C243 vdd gnd 0.3609f
C244 a_880_137# clk 0.00117f
C245 s3 temp105 0.00413f
C246 w_878_8# b4 0.00793f
C247 g1_inv mid_s2 0.28839f
C248 w_264_8# a_266_137# 0.03596f
C249 b2_inv b2 0.06519f
C250 a0 a_140_171# 0.00256f
C251 b1_inv a1 0.03149f
C252 temp107 p2_inv 0
C253 p1_inv b1 0.18651f
C254 vdd a_352_46# 0
C255 clk a_182_44# 0.08021f
C256 temp100 vdd 0.00149f
C257 a_125_272# gnd 0.04228f
C258 temp110 w_628_378# 0.01229f
C259 a_308_528# vdd 0.00148f
C260 w_432_9# a_434_70# 0.0271f
C261 a_266_137# clk 0.00117f
C262 a_348_138# gnd 0.0011f
C263 a_434_138# vdd 0.00155f
C264 w_63_186# mid_s0 0.0137f
C265 s4 a_848_245# 0
C266 c5_out a_837_618# 0.05934f
C267 w_524_189# g2_inv 0.00689f
C268 g1_inv temp104 0.05029f
C269 a_742_502# s4 0.03186f
C270 mid_s3 a3 0.26686f
C271 s3 g1_inv 0.00505f
C272 a_125_272# temp100 0.04402f
C273 s0_out a_6_464# 0.05934f
C274 vdd w_522_446# 0.00658f
C275 clk a_602_69# 0.00836f
C276 vdd a_772_69# 0.00148f
C277 gnd a_686_69# 0.00145f
C278 gnd w_323_433# 0
C279 temp109 vdd 0.00443f
C280 g2_inv p4 0.01191f
C281 g3_inv gnd 0.06335f
C282 s1_inv s1_out 0.04402f
C283 a_837_550# vdd 0.00148f
C284 a_778_548# gnd 0
C285 a_601_174# vdd 0
C286 b4 gnd 0.02061f
C287 c0 a1 0.01398f
C288 c5 w_908_310# 0.01323f
C289 c5_inv c5_out 0.04402f
C290 s2_out a_308_622# 0.05934f
C291 temp102 p0_inv 0
C292 a_348_70# a_348_44# 0.03186f
C293 vdd a_182_70# 0.00148f
C294 gnd a_21_68# 0.00145f
C295 clk a_881_87# 0.02938f
C296 s0 gnd 0.00153f
C297 c1 w_348_337# 0
C298 temp108 temp106 0.18136f
C299 a_778_573# gnd 0
C300 a_743_571# vdd 0.00127f
C301 w_432_9# a_435_88# 0.02689f
C302 a_309_572# clk 0.02938f
C303 a_449_174# vdd 0
C304 a4 a_776_139# 0.00529f
C305 b3 gnd 0.02062f
C306 a_7_414# gnd 0.00473f
C307 p2_inv a_535_452# 0
C308 w_63_186# g0_inv 0.01272f
C309 s0_out w_4_335# 0.02904f
C310 p3_inv a_501_317# 0
C311 temp108 w_419_492# 0.04473f
C312 a_655_554# w_652_450# 0.03401f
C313 gnd a_722_89# 0
C314 s4 clk 0.07184f
C315 g2_inv a_359_313# 0.10283f
C316 p0_inv s1 0.00143f
C317 temp107 a_538_529# 0.04402f
C318 s3 c3 0.26815f
C319 a_742_596# vdd 0.00155f
C320 a_309_597# clk 0.03055f
C321 c4_inv w_908_310# 0.03794f
C322 a2 vdd 0.05449f
C323 a_602_43# a3_in 0.03186f
C324 a_6_396# w_4_335# 0.0271f
C325 a_107_452# vdd 0.0012f
C326 temp102 gnd 0.0587f
C327 w_223_186# b1_inv 0.00602f
C328 g1_inv p0_inv 0.00305f
C329 clk b4_in 0.07604f
C330 a_881_87# a_880_69# 0.05922f
C331 w_432_9# a2_in 0.0205f
C332 a_654_579# w_652_450# 0.03596f
C333 a_838_593# w_835_489# 0.03401f
C334 gnd a_384_90# 0
C335 mid_s1 b1 0.00216f
C336 temp105 gnd 0.02554f
C337 c1 vdd 0.0027f
C338 p0_inv w_88_314# 0.02587f
C339 s4_inv vdd 0
C340 a_308_622# clk 0.00117f
C341 b2_inv gnd 0.11715f
C342 b3 a_601_174# 0
C343 a_107_477# gnd 0.00483f
C344 a_520_87# a_519_69# 0.05922f
C345 vdd a_776_21# 0
C346 c4_in w_676_255# 0.01285f
C347 p3_inv temp110 0.04166f
C348 clk a_687_112# 0.03055f
C349 vdd a_881_112# 0.00127f
C350 vdd w_676_255# 0.02913f
C351 c4_out w_652_450# 0.02904f
C352 a_837_618# w_835_489# 0.03596f
C353 gnd a_773_112# 0.00483f
C354 s2 a_336_401# 0.00457f
C355 s1 gnd 0.01317f
C356 a_10_372# vdd 0
C357 c4_in mid_s4 0.10447f
C358 s3 temp107 0
C359 a_654_511# c4_in 0
C360 a_512_660# vdd 0.0012f
C361 a_547_662# gnd 0
C362 w_346_9# a_349_113# 0.03401f
C363 a_512_685# clk 0.03055f
C364 a_174_260# gnd 0
C365 a_348_44# b1_in 0.03186f
C366 mid_s4 vdd 0.23424f
C367 w_223_186# c0 0.04206f
C368 g2_inv p1_inv 0.00143f
C369 a_837_524# clk 0.08021f
C370 a_654_511# vdd 0.00148f
C371 g1_inv gnd 0.22719f
C372 vdd a_438_22# 0
C373 temp105 w_522_446# 0.01854f
C374 a_660_386# p3_inv 0.00379f
C375 c2 a_359_313# 0.05926f
C376 g2_inv w_372_189# 0.01657f
C377 gnd a_555_114# 0
C378 clk a_435_113# 0.03055f
C379 c5_inv w_835_489# 0.00611f
C380 vdd w_348_337# 0.0242f
C381 p4 a_549_279# 0.01073f
C382 a_110_410# vdd 0
C383 b2 a3 0.02273f
C384 w_878_8# a_880_137# 0.03596f
C385 a_690_531# c4_in 0
C386 g4_inv a_994_214# 0.00255f
C387 w_180_9# a_183_113# 0.03401f
C388 w_600_8# clk 0.05738f
C389 p4_inv vdd 0.00125f
C390 w_770_8# vdd 0.0391f
C391 gnd a_772_43# 0.00167f
C392 clk a_686_43# 0.08021f
C393 vdd a_880_43# 0.00148f
C394 mid_s0 w_17_273# 0.08752f
C395 temp100 w_88_314# 0.02706f
C396 c0 mid_s0 0.1045f
C397 w_346_9# a_348_44# 0.02662f
C398 a_511_642# w_509_581# 0.0271f
C399 gnd a_183_113# 0.00483f
C400 a_742_528# w_740_467# 0.0271f
C401 mid_s4 b4 0.00216f
C402 g2_inv mid_s3 0.00261f
C403 a_848_245# b4_inv 0
C404 g4_inv a_994_256# 0
C405 w_517_8# a_519_137# 0.03596f
C406 w_98_6# vdd 0.03895f
C407 g2_inv p2_inv 0.15936f
C408 vdd a_606_45# 0
C409 clk a_434_44# 0.08021f
C410 a_819_336# gnd 0
C411 c4_in vdd 1.51439f
C412 temp111 w_806_368# 0.02095f
C413 c3 gnd 0.05598f
C414 a_772_137# clk 0.00117f
C415 a_106_502# clk 0.00117f
C416 a_880_137# gnd 0.00158f
C417 w_180_9# a_182_44# 0.02662f
C418 a_511_710# w_509_581# 0.03596f
C419 s3 a_535_452# 0
C420 p2_inv w_532_506# 0.0225f
C421 p4_inv b4 0.18651f
C422 b2_inv a2 0.03149f
C423 a_772_69# a_772_43# 0.03186f
C424 p1_inv a1 0.04811f
C425 gnd a_182_44# 0.00167f
C426 vdd a_270_45# 0
C427 p1_inv a_231_438# 0.11558f
C428 a_125_272# vdd 0.00147f
C429 s4 w_837_269# 0.0154f
C430 temp105 c1 0.22788f
C431 s1_out a_106_502# 0.05934f
C432 c0 p3_inv 0.00237f
C433 s1_inv gnd 0
C434 a_776_139# a_772_137# 0.05922f
C435 a_348_138# vdd 0.00155f
C436 a_266_137# gnd 0.0011f
C437 a_312_530# vdd 0
C438 w_878_8# a_881_87# 0.02689f
C439 a_100_135# clk 0.00117f
C440 c0 b3_inv 0
C441 p1_inv a_379_391# 0.00243f
C442 a_106_434# a_106_408# 0.03186f
C443 a_107_452# s1 0.01742f
C444 g0_inv c0 0.00873f
C445 c5 g4_inv 0.05029f
C446 vdd a_686_69# 0.00148f
C447 gnd a_602_69# 0.00145f
C448 clk a_519_69# 0.00836f
C449 vdd w_323_433# 0.02806f
C450 temp111 gnd 0.00161f
C451 g3_inv vdd 0.16491f
C452 a_640_359# w_628_378# 0.02507f
C453 s1 c1 0.25037f
C454 temp106 a_430_473# 0.02579f
C455 b4 vdd 0.06596f
C456 a_655_554# clk 0.03055f
C457 a4 gnd 0.02158f
C458 temp107 gnd 0.00161f
C459 w_517_8# a_520_87# 0.02689f
C460 temp113 g4_inv 0.21433f
C461 g1_inv c1 0.00816f
C462 clk a_773_87# 0.02938f
C463 vdd a_21_68# 0.00148f
C464 w_878_8# b4_in 0.0205f
C465 gnd a_881_87# 0.00473f
C466 g1_inv a_493_482# 0
C467 a_837_524# c5 0.03186f
C468 a_430_473# w_419_492# 0.02507f
C469 s2 a_359_313# 0
C470 s0 vdd 0.01285f
C471 c1 w_88_314# 0.01272f
C472 a3 gnd 0.02239f
C473 a_309_572# gnd 0.00473f
C474 a_654_579# clk 0.00117f
C475 b3 vdd 0.13824f
C476 w_524_189# p3_inv 0.00598f
C477 a_42_416# gnd 0
C478 a_106_434# clk 0.00836f
C479 a_7_414# vdd 0.0012f
C480 a_182_70# a_182_44# 0.03186f
C481 s2_out w_306_493# 0.02904f
C482 w_524_189# b3_inv 0.00602f
C483 w_264_8# a1 0.00991f
C484 s0_inv w_4_335# 0.00611f
C485 p3_inv p4 0.00228f
C486 w_517_8# b2_in 0.0205f
C487 gnd a_638_89# 0
C488 a_838_568# w_835_489# 0.02689f
C489 a_538_529# w_532_506# 0.02507f
C490 a_658_463# vdd 0
C491 s4 gnd 0.00153f
C492 c0 a_220_353# 0.052f
C493 a_110_410# s1 0
C494 a_515_594# vdd 0
C495 a_140_171# vdd 0
C496 a_309_597# gnd 0.00483f
C497 b1 gnd 0.02142f
C498 w_770_8# a_773_112# 0.03401f
C499 a_222_261# w_211_285# 0.00598f
C500 p4_inv w_908_310# 0.0188f
C501 mid_s3 w_543_295# 0.08921f
C502 temp102 vdd 0.02272f
C503 a_142_454# gnd 0
C504 s3_out a_511_710# 0.05934f
C505 gnd b4_in 0.00153f
C506 clk a4_in 0.07604f
C507 mid_s3 a_549_279# 0.07934f
C508 w_223_186# p1_inv 0.00598f
C509 clk a_183_88# 0.02938f
C510 gnd a_302_89# 0
C511 c3 c1 0.14747f
C512 temp105 vdd 0.00149f
C513 mid_s1 a1 0.26686f
C514 g3_inv b3 0.05029f
C515 a_220_353# w_208_373# 0.03382f
C516 a3 a_601_174# 0.00256f
C517 a_515_618# vdd 0
C518 a_308_622# gnd 0.0011f
C519 g4_inv gnd 0.11946f
C520 g2_inv b2 0.05029f
C521 s2 p1_inv 0.00147f
C522 a_107_477# vdd 0.00127f
C523 a_142_479# gnd 0
C524 vdd a_690_21# 0
C525 c4_in w_908_310# 0.02087f
C526 gnd a_687_112# 0.00483f
C527 w_770_8# a_772_43# 0.02662f
C528 clk a_603_112# 0.03055f
C529 vdd a_773_112# 0.00127f
C530 vdd w_908_310# 0.03499f
C531 temp106 a_586_466# 0.04407f
C532 s3 w_532_506# 0.00134f
C533 a_6_396# clk 0.00836f
C534 s1 vdd 0.01095f
C535 mid_s0 b0 0.00216f
C536 temp102 w_323_433# 0.0188f
C537 a_512_685# gnd 0.00483f
C538 a0 a_100_135# 0.05949f
C539 b0 a_182_138# 0.05951f
C540 w_63_186# c0 0.04206f
C541 clk w_306_493# 0.04117f
C542 temp106 p1_inv 0
C543 g1_inv vdd 0.01939f
C544 a_837_524# gnd 0.00167f
C545 a_349_88# a_348_70# 0.05922f
C546 vdd a_352_22# 0
C547 clk b0_in 0.076f
C548 temp112 w_806_368# 0.01272f
C549 temp104 a_694_386# 0.00105f
C550 c2 mid_s2 0.07239f
C551 a_640_359# p3_inv 0.00315f
C552 gnd a_435_113# 0.00483f
C553 clk a_349_113# 0.03055f
C554 vdd w_88_314# 0.03499f
C555 w_517_8# clk 0.05738f
C556 w_684_8# vdd 0.0391f
C557 b2 a_483_221# 0
C558 a_450_500# vdd 0
C559 clk a_602_43# 0.08021f
C560 vdd a_772_43# 0.00148f
C561 gnd a_686_43# 0.00167f
C562 a_125_272# w_88_314# 0.02507f
C563 c0 c0_inv 0.04402f
C564 vdd a_183_113# 0.00127f
C565 gnd a_218_115# 0
C566 c0 a_21_136# 0.05946f
C567 g1_inv w_323_433# 0.02491f
C568 w_883_182# gnd 0
C569 w_19_7# vdd 0.03913f
C570 mid_s4 a4 0.27149f
C571 b1 a2 0.03341f
C572 temp106 p2_inv 0.00462f
C573 a_837_550# a_837_524# 0.03186f
C574 a_743_546# a_742_528# 0.05922f
C575 g0_inv b0 0.05141f
C576 p1_inv g0_inv 0.20726f
C577 clk a_348_44# 0.08021f
C578 gnd a_434_44# 0.00167f
C579 vdd a_523_45# 0
C580 temp112 gnd 0.03272f
C581 a_379_391# temp104 0.11558f
C582 a_880_137# vdd 0.00155f
C583 a_106_502# gnd 0.0011f
C584 a_686_137# clk 0.00117f
C585 c3 vdd 0.04237f
C586 a_772_137# gnd 0.0011f
C587 s2 clk 0.07184f
C588 w_684_8# a_686_69# 0.0271f
C589 w_223_186# mid_s1 0.0137f
C590 s3_out w_509_581# 0.02904f
C591 c0 a_689_223# 0
C592 b0 a_174_218# 0
C593 p4_inv a4 0.04812f
C594 p1_inv temp103 0.01238f
C595 vdd a_182_44# 0.00148f
C596 clk w_835_489# 0.04117f
C597 a_28_249# gnd 0.12166f
C598 a_125_300# vdd 0
C599 p3_inv w_429_320# 0.01919f
C600 a_100_135# gnd 0.0011f
C601 s3 w_543_295# 0.01368f
C602 w_346_9# a_348_70# 0.0271f
C603 s1_inv vdd 0
C604 a_182_138# clk 0.00117f
C605 g2_inv gnd 0.14693f
C606 a_266_137# vdd 0.00155f
C607 p3_inv mid_s3 0.00541f
C608 c0 a_300_171# 0.00379f
C609 s4 mid_s4 0.00216f
C610 a_511_642# a_511_616# 0.03186f
C611 mid_s3 b3_inv 0
C612 p1_inv a_379_419# 0.00379f
C613 s3 a_549_279# 0
C614 temp102 s1 0.07482f
C615 p2_inv p3_inv 0.2242f
C616 w_684_8# b3 0.00793f
C617 c5 a_973_272# 0.00105f
C618 g3_inv a_819_336# 0
C619 clk a_434_70# 0.00836f
C620 g1_inv temp102 0.00473f
C621 gnd a_519_69# 0.00145f
C622 vdd a_602_69# 0.00148f
C623 vdd w_251_453# 0.01458f
C624 temp111 vdd 0.00149f
C625 temp104 w_628_378# 0.04027f
C626 a_760_348# gnd 0.04275f
C627 temp108 a_430_473# 0.11558f
C628 b4_inv gnd 0.11731f
C629 a_308_554# clk 0.00836f
C630 temp107 vdd 0.72137f
C631 b4 a_880_137# 0.05946f
C632 a_655_554# gnd 0.00483f
C633 w_19_7# a_21_68# 0.0271f
C634 a4 vdd 0.00611f
C635 g4_inv w_676_255# 0.03965f
C636 c0 b1_inv 0
C637 a_266_69# a_266_43# 0.03186f
C638 w_517_8# b2 0.00787f
C639 c4_out c4_inv 0.04402f
C640 a_6_464# w_4_335# 0.03596f
C641 clk a_687_87# 0.02938f
C642 gnd a_773_87# 0.00473f
C643 vdd a_881_87# 0.0012f
C644 a_743_546# w_740_467# 0.02689f
C645 temp106 w_573_460# 0.03572f
C646 s2 mid_s2 0.24927f
C647 a_10_348# vdd 0
C648 a_694_386# gnd 0.0186f
C649 a_6_396# a_6_370# 0.03186f
C650 a_309_572# vdd 0.0012f
C651 a_880_43# b4_in 0.03186f
C652 g2_inv a_601_174# 0.00255f
C653 a_654_579# gnd 0.0011f
C654 a_483_221# gnd 0
C655 a3 vdd 0.07859f
C656 w_346_9# a_349_88# 0.02689f
C657 p1_inv w_281_365# 0.03954f
C658 a_106_434# gnd 0.00145f
C659 s2_inv w_306_493# 0.00611f
C660 p4_inv g4_inv 0.0042f
C661 temp111 g3_inv 0.24165f
C662 s4 c4_in 0.31123f
C663 gnd a_555_89# 0
C664 a_742_528# a_742_502# 0.03186f
C665 clk a_435_88# 0.02938f
C666 s2 temp104 0.00544f
C667 s4 vdd 0.01558f
C668 c0 w_17_273# 0.0302f
C669 s1 w_88_314# 0.00131f
C670 c2 gnd 0.07025f
C671 a1 gnd 0.02239f
C672 a4 b4 0.44199f
C673 a_309_597# vdd 0.00127f
C674 c4_out gnd 0.01932f
C675 a_519_43# b2_in 0.03186f
C676 b1 vdd 0.0926f
C677 w_180_9# a_183_88# 0.02689f
C678 a_106_408# w_104_373# 0.02662f
C679 a_231_438# gnd 0.04227f
C680 a_773_87# a_772_69# 0.05922f
C681 w_63_186# b0 0.16141f
C682 vdd b4_in 0.00145f
C683 gnd a4_in 0.00153f
C684 clk b3_in 0.07604f
C685 a_694_386# temp109 0.05029f
C686 gnd a_183_88# 0.00473f
C687 w_346_9# b1_in 0.0205f
C688 a_450_500# g1_inv 0.00255f
C689 a_535_452# vdd 0
C690 a_379_391# gnd 0.04275f
C691 c4_in g4_inv 0.31767f
C692 g3_inv a3 0.00105f
C693 c0 w_208_373# 0.02076f
C694 s3 temp106 0.00472f
C695 a_308_622# vdd 0.00155f
C696 b1 a_348_138# 0.05946f
C697 a_511_642# clk 0.00836f
C698 a_973_272# gnd 0.00163f
C699 c5_out gnd 0.01932f
C700 g2_inv a2 0.00105f
C701 g4_inv vdd 0.01715f
C702 s0_out gnd 0.01932f
C703 clk a2_in 0.076f
C704 vdd a_606_21# 0
C705 w_883_182# mid_s4 0.0137f
C706 a_654_485# w_652_450# 0.02662f
C707 a_640_359# temp110 0.04402f
C708 gnd a_603_112# 0.00483f
C709 clk a_520_112# 0.03055f
C710 w_180_9# b0_in 0.0205f
C711 vdd a_687_112# 0.00127f
C712 vdd w_728_296# 0.00683f
C713 g2_inv c1 0.00582f
C714 a_110_386# vdd 0
C715 a_6_396# gnd 0.00145f
C716 mid_s0 a0 0.26686f
C717 a_28_249# b0_inv 0
C718 c5 w_835_489# 0.0205f
C719 a_734_309# vdd 0
C720 w_264_8# a_267_112# 0.03401f
C721 a3 b3 0.61948f
C722 a_511_710# clk 0.00117f
C723 a_266_43# a1_in 0.03186f
C724 a_549_279# gnd 0.13193f
C725 a_512_685# vdd 0.00127f
C726 a_547_687# gnd 0
C727 w_524_189# c0 0.03504f
C728 clk w_104_373# 0.04117f
C729 g2_inv a_493_482# 0
C730 c3 g1_inv 0.00167f
C731 a_742_528# clk 0.00836f
C732 a_837_524# vdd 0.00148f
C733 w_883_182# p4_inv 0.00598f
C734 gnd b0_in 0.00153f
C735 vdd a_270_21# 0
C736 mid_s1 w_211_285# 0.09579f
C737 temp104 p3_inv 0.00145f
C738 c0 p4 0.21413f
C739 clk a_267_112# 0.03055f
C740 gnd a_349_113# 0.00483f
C741 a_511_616# w_509_581# 0.02662f
C742 vdd a_435_113# 0.00127f
C743 vdd w_747_370# 0.01372f
C744 g3_inv g4_inv 0
C745 a_742_502# w_740_467# 0.02662f
C746 a_308_528# w_306_493# 0.02662f
C747 w_600_8# vdd 0.0391f
C748 g4_inv b4 0.05141f
C749 w_432_9# clk 0.05736f
C750 w_770_8# a_772_137# 0.03596f
C751 s1_out w_104_373# 0.02904f
C752 clk a_519_43# 0.08021f
C753 vdd a_686_43# 0.00148f
C754 a_183_88# a_182_70# 0.05922f
C755 a_107_452# a_106_434# 0.05922f
C756 gnd a_602_43# 0.00167f
C757 g3_inv w_728_296# 0.00221f
C758 a_220_353# temp101 0.00105f
C759 gnd a_136_112# 0
C760 clk a_22_111# 0.03055f
C761 g2_inv w_348_337# 0
C762 w_264_8# a_266_43# 0.02662f
C763 g3_inv a_734_309# 0
C764 a_21_42# c0_in 0.03186f
C765 mid_s4 b4_inv 0
C766 w_883_182# vdd 0.05711f
C767 temp113 a_723_223# 0
C768 temp103 temp104 0.00105f
C769 temp107 g1_inv 0.00108f
C770 g0_inv a0 0.00148f
C771 temp112 c4_in 0.25842f
C772 vdd a_434_44# 0.00148f
C773 p1_inv a_259_438# 0
C774 clk a_266_43# 0.08021f
C775 gnd a_348_44# 0.00167f
C776 temp109 w_628_378# 0.03958f
C777 a_694_348# gnd 0
C778 temp101 w_281_365# 0.01854f
C779 temp112 vdd 0.00141f
C780 c1 c2 0
C781 a_379_419# temp104 0
C782 a_602_137# clk 0.00117f
C783 a_106_502# vdd 0.00155f
C784 a_686_137# gnd 0.0011f
C785 a_772_137# vdd 0.00155f
C786 s3_inv w_509_581# 0.00611f
C787 s2 gnd 0.00224f
C788 a_686_69# a_686_43# 0.03186f
C789 w_180_9# a_182_138# 0.03596f
C790 p4_inv b4_inv 0.00746f
C791 w_98_6# a_100_135# 0.03596f
C792 vdd a_186_46# 0
C793 clk a_21_42# 0.08021f
C794 clk w_740_467# 0.04117f
C795 a_28_249# vdd 0
C796 mid_s0 gnd 0.18444f
C797 a_308_528# s2 0.03186f
C798 a_100_135# vdd 0.00155f
C799 a_21_136# clk 0.00117f
C800 temp106 gnd 0.0587f
C801 w_770_8# a_773_87# 0.02689f
C802 a_182_138# gnd 0.0011f
C803 g2_inv vdd 0.03168f
C804 a_142_454# s1 0
C805 w_883_182# b4 0.16141f
C806 g0_inv p0_inv 0.02913f
C807 a_7_439# w_4_335# 0.03401f
C808 g1_inv b1 0.05029f
C809 a_441_300# p4 0.04402f
C810 g3_inv temp112 0.05732f
C811 temp109 a_694_348# 0
C812 vdd a_519_69# 0.00148f
C813 clk a_348_70# 0.00836f
C814 gnd a_434_70# 0.00145f
C815 a_655_554# c4_in 0
C816 vdd w_532_506# 0.01458f
C817 clk w_509_581# 0.04117f
C818 c2 w_348_337# 0.08762f
C819 a_760_348# vdd 0.00147f
C820 a_723_223# gnd 0
C821 a_655_554# vdd 0.00127f
C822 a_308_554# gnd 0.00145f
C823 g4_inv w_908_310# 0.02076f
C824 c0 b0 0.01065f
C825 p1_inv c0 0.00237f
C826 gnd a_687_87# 0.00473f
C827 vdd a_773_87# 0.0012f
C828 w_770_8# a4_in 0.0205f
C829 a_837_550# w_835_489# 0.0271f
C830 clk a_603_87# 0.02938f
C831 temp106 w_522_446# 0.00218f
C832 a_654_579# c4_in 0
C833 g2_inv g3_inv 0.1815f
C834 a_694_386# vdd 0.00106f
C835 p3_inv gnd 1.60189f
C836 c0 w_372_189# 0.03504f
C837 a_110_386# s1 0
C838 a_654_579# vdd 0.00155f
C839 a_308_554# a_308_528# 0.03186f
C840 a_838_593# clk 0.03055f
C841 a_344_574# gnd 0
C842 b3_inv gnd 0.29079f
C843 a_106_434# vdd 0.00148f
C844 g0_inv gnd 0.18961f
C845 c4_inv a_945_268# 0.11558f
C846 s0 a_28_249# 0
C847 gnd a_435_88# 0.00473f
C848 clk a_349_88# 0.02938f
C849 c4_out c4_in 0.00549f
C850 c2 vdd 0.0602f
C851 a_654_485# clk 0.08021f
C852 a_344_599# gnd 0
C853 a_837_618# clk 0.00117f
C854 c4_out vdd 0.00149f
C855 w_684_8# a_687_112# 0.03401f
C856 g2_inv b3 0.00651f
C857 g0_inv temp100 0.18509f
C858 b4_inv b4 0.06519f
C859 a1 vdd 0.02221f
C860 c0 mid_s3 0
C861 a_6_464# clk 0.00117f
C862 temp103 gnd 0.00161f
C863 a_231_438# vdd 0
C864 p2_inv c0 0.00237f
C865 w_63_186# a0 0.08036f
C866 s3_inv s3_out 0.04402f
C867 clk a3_in 0.07604f
C868 vdd a4_in 0.00151f
C869 gnd b3_in 0.00153f
C870 p3_inv temp109 0.11703f
C871 gnd a_218_90# 0
C872 vdd a_183_88# 0.0012f
C873 p2_inv a_538_519# 0
C874 s2 c1 0.00156f
C875 mid_s1 b1_inv 0
C876 a_379_391# vdd 0
C877 p0_inv w_281_365# 0.0188f
C878 a_511_642# gnd 0.00145f
C879 c5_out vdd 0.00149f
C880 a_945_268# gnd 0.04228f
C881 a_973_272# vdd 0.00149f
C882 s0_inv gnd 0
C883 s0_out vdd 0.00149f
C884 clk b1_in 0.076f
C885 gnd a2_in 0.00153f
C886 vdd a_523_21# 0
C887 c2 w_323_433# 0.00606f
C888 w_684_8# a_686_43# 0.02662f
C889 s3 w_509_581# 0.02042f
C890 gnd a_520_112# 0.00483f
C891 vdd a_603_112# 0.00127f
C892 s4_out w_740_467# 0.02904f
C893 temp106 c1 0
C894 vdd w_543_295# 0.00819f
C895 gnd w_211_285# 0
C896 a_220_353# gnd 0.02012f
C897 a_6_396# vdd 0.00148f
C898 mid_s0 b0_inv 0
C899 a_511_710# gnd 0.0011f
C900 vdd w_306_493# 0.04561f
C901 clk w_4_335# 0.04117f
C902 a_464_294# gnd 0
C903 w_63_186# p0_inv 0.00598f
C904 temp106 a_493_482# 0.00255f
C905 a_742_528# gnd 0.00145f
C906 a_841_526# vdd 0
C907 w_524_189# mid_s3 0.0137f
C908 a_267_87# a_266_69# 0.05922f
C909 vdd b0_in 0.00149f
C910 clk a_104_19# 0
C911 p4 w_429_320# 0.0062f
C912 a_379_391# w_323_433# 0.02507f
C913 temp104 a_660_386# 0
C914 c0 mid_s1 0
C915 vdd a_349_113# 0.00127f
C916 gnd a_267_112# 0.00483f
C917 clk a_101_110# 0.03055f
C918 s2 w_348_337# 0.01483f
C919 vdd w_628_378# 0.03996f
C920 gnd w_281_365# 0
C921 p4 mid_s3 0.00162f
C922 mid_s1 a_222_261# 0.06095f
C923 w_346_9# clk 0.05736f
C924 w_517_8# vdd 0.03894f
C925 p2_inv p4 0.00759f
C926 g4_inv a4 0.00148f
C927 g2_inv g1_inv 0.00169f
C928 gnd a_519_43# 0.00167f
C929 vdd a_602_43# 0.00148f
C930 a_441_300# w_429_320# 0.03382f
C931 c0 temp101 0.17673f
C932 p0_inv c0_inv 0.20208f
C933 gnd a_22_111# 0.00483f
C934 temp109 a_464_294# 0
C935 g1_inv w_532_506# 0.02992f
C936 w_432_9# a_434_138# 0.03596f
C937 w_223_186# vdd 0.05711f
C938 g0_inv c1 0.05029f
C939 temp112 a_819_336# 0.00128f
C940 vdd a_348_44# 0.00148f
C941 gnd a_266_43# 0.00167f
C942 clk a_100_41# 0.08022f
C943 temp111 w_747_370# 0.0062f
C944 temp101 w_208_373# 0.02095f
C945 w_600_8# a_602_69# 0.0271f
C946 s2 vdd 0.00222f
C947 c0 mid_s2 0
C948 a_686_137# vdd 0.00155f
C949 a_519_137# clk 0.00117f
C950 a_602_137# gnd 0.0011f
C951 temp102 a_379_391# 0.02579f
C952 a_7_414# a_6_396# 0.05922f
C953 a_106_434# s1 0.01693f
C954 gnd a_21_42# 0.00167f
C955 vdd a_104_43# 0
C956 vdd w_835_489# 0.04561f
C957 clk w_652_450# 0.04117f
C958 c0_inv gnd 0.00141f
C959 mid_s0 vdd 0.23424f
C960 temp106 vdd 0.07853f
C961 a_743_546# clk 0.02938f
C962 w_264_8# a_266_69# 0.0271f
C963 temp108 gnd 0.0015f
C964 g2_inv c3 0.00153f
C965 a_21_136# gnd 0.0011f
C966 a_182_138# vdd 0.00155f
C967 c0 b2 0.01731f
C968 w_600_8# a3 0.00965f
C969 w_883_182# a4 0.08036f
C970 p1_inv a_294_371# 0
C971 s3 a_538_519# 0.00218f
C972 g1_inv a1 0.00105f
C973 a_107_452# w_104_373# 0.02689f
C974 temp111 temp112 0.00178f
C975 s2 w_323_433# 0.00122f
C976 gnd a_348_70# 0.00145f
C977 vdd a_434_70# 0.00148f
C978 clk a_266_69# 0.00836f
C979 vdd w_419_492# 0.02865f
C980 a_760_376# vdd 0
C981 c1 w_211_285# 0.0248f
C982 temp110 gnd 0.2043f
C983 a_308_554# vdd 0.00148f
C984 a_690_556# gnd 0
C985 a_838_568# clk 0.02938f
C986 a_973_272# w_908_310# 0.02706f
C987 g4_inv w_728_296# 0.00852f
C988 a_689_223# gnd 0
C989 c0 a0 0.01398f
C990 a_512_660# a_511_642# 0.05922f
C991 w_432_9# a2 0.00892f
C992 a_100_67# a_100_41# 0.03186f
C993 temp101 a_441_300# 0.00105f
C994 gnd a_603_87# 0.00473f
C995 p2_inv p1_inv 0.2544f
C996 clk a_520_87# 0.02938f
C997 vdd a_687_87# 0.0012f
C998 p3_inv vdd 0.03907f
C999 a_838_593# gnd 0.00483f
C1000 temp107 g2_inv 0.17633f
C1001 w_264_8# a_267_87# 0.02689f
C1002 b3 a_686_137# 0.05946f
C1003 a_772_43# a4_in 0.03186f
C1004 a_6_370# w_4_335# 0.02662f
C1005 c0 temp113 0.05029f
C1006 a_7_439# clk 0.03055f
C1007 g0_inv vdd 0.03963f
C1008 p2_inv w_372_189# 0.00598f
C1009 p4_inv a_945_268# 0.02579f
C1010 c4_inv a_945_296# 0
C1011 s4 temp112 0.00746f
C1012 a_760_348# temp111 0.04402f
C1013 s0 mid_s0 0.00216f
C1014 a_743_571# w_740_467# 0.03401f
C1015 gnd a_349_88# 0.00473f
C1016 temp107 w_532_506# 0.03721f
C1017 vdd a_435_88# 0.0012f
C1018 clk a_267_87# 0.02938f
C1019 a_746_480# vdd 0
C1020 a_654_485# gnd 0.00167f
C1021 g2_inv a3 0.00625f
C1022 p0_inv c0 0.04024f
C1023 a_837_618# gnd 0.0011f
C1024 a_511_616# clk 0.08021f
C1025 b4_inv a4 0.03149f
C1026 b1_inv gnd 0.11715f
C1027 b2 a_519_137# 0.05946f
C1028 s2 temp102 0.00472f
C1029 p2_inv w_429_320# 0.01887f
C1030 temp103 vdd 0.72137f
C1031 a_6_464# gnd 0.0011f
C1032 w_63_186# b0_inv 0.00602f
C1033 w_883_182# g4_inv 0.01272f
C1034 vdd b3_in 0.00151f
C1035 gnd a3_in 0.00153f
C1036 a_687_87# a_686_69# 0.05922f
C1037 clk b2_in 0.07604f
C1038 p2_inv mid_s3 0
C1039 mid_s2 a_359_313# 0.02788f
C1040 p3_inv g3_inv 0.01724f
C1041 w_264_8# a1_in 0.0205f
C1042 gnd a_136_87# 0
C1043 a_742_596# w_740_467# 0.03596f
C1044 clk a_22_86# 0.02938f
C1045 a_336_401# gnd 0
C1046 temp112 g4_inv 0.02579f
C1047 a_379_419# vdd 0
C1048 c5_inv gnd 0
C1049 a_511_642# vdd 0.00148f
C1050 a_945_268# vdd 0.00147f
C1051 a1 a_266_137# 0.05946f
C1052 a_742_502# clk 0.08021f
C1053 s0_inv vdd 0
C1054 vdd a2_in 0.00149f
C1055 clk a1_in 0.07604f
C1056 gnd b1_in 0.00153f
C1057 temp112 w_728_296# 0.0188f
C1058 w_223_186# g1_inv 0.01272f
C1059 a_586_466# w_573_460# 0.03382f
C1060 vdd a_520_112# 0.00127f
C1061 c3 w_543_295# 0.02557f
C1062 gnd a_916_114# 0
C1063 vdd w_211_285# 0.00819f
C1064 s4_inv w_740_467# 0.00611f
C1065 temp106 temp105 0.00233f
C1066 c0 gnd 0.10021f
C1067 p4 temp113 0.00105f
C1068 a_106_408# clk 0.08021f
C1069 p3_inv b3 0.1865f
C1070 a_220_353# vdd 0.00106f
C1071 temp103 w_323_433# 0.02095f
C1072 a_231_438# w_251_453# 0.02507f
C1073 a_511_710# vdd 0.00155f
C1074 p1_inv temp101 0.11558f
C1075 c3 a_549_279# 0.02788f
C1076 s3_out gnd 0.01932f
C1077 a_100_41# a0_in 0.03186f
C1078 vdd w_104_373# 0.04561f
C1079 b3_inv b3 0.06519f
C1080 a_222_261# gnd 0.30199f
C1081 s2 g1_inv 0.08624f
C1082 a_742_528# vdd 0.00148f
C1083 clk c0_in 0.07192f
C1084 vdd a_186_22# 0
C1085 temp104 a_640_359# 0.11558f
C1086 g2_inv w_728_296# 0
C1087 vdd w_281_365# 0.00658f
C1088 vdd a_267_112# 0.00127f
C1089 gnd w_208_373# 0.00177f
C1090 gnd a_101_110# 0.00483f
C1091 w_264_8# clk 0.05738f
C1092 w_432_9# vdd 0.0391f
C1093 w_684_8# a_686_137# 0.03596f
C1094 a_182_44# b0_in 0.03186f
C1095 temp106 g1_inv 0
C1096 vdd a_519_43# 0.00148f
C1097 temp101 w_429_320# 0.02101f
C1098 mid_s2 w_372_189# 0.0137f
C1099 gnd a_57_113# 0
C1100 a_512_660# w_509_581# 0.02689f
C1101 vdd a_22_111# 0.00127f
C1102 g2_inv w_747_370# 0.01921f
C1103 c4_inv w_652_450# 0.0062f
C1104 c0 a_601_174# 0.00379f
C1105 a_655_529# w_652_450# 0.02689f
C1106 g1_inv w_419_492# 0.0037f
C1107 a_511_616# s3 0.03186f
C1108 w_63_186# vdd 0.05711f
C1109 p1_inv temp104 0.00782f
C1110 a1 b1 0.57772f
C1111 a_538_529# p2_inv 0.11558f
C1112 temp103 temp102 0
C1113 vdd a_266_43# 0.00148f
C1114 gnd a_100_41# 0.00167f
C1115 a_760_348# w_747_370# 0.02507f
C1116 a_501_317# vdd 0
C1117 p4 gnd 0.00474f
C1118 c0 a_243_347# 0.00234f
C1119 a_430_473# gnd 0.04275f
C1120 a_312_506# vdd 0
C1121 a_519_137# gnd 0.0011f
C1122 a_602_137# vdd 0.00155f
C1123 b2 w_372_189# 0.16276f
C1124 c0 a_449_174# 0.00379f
C1125 g0_inv s1 0.02777f
C1126 a0 b0 0.53596f
C1127 a_309_572# w_306_493# 0.02689f
C1128 a_602_69# a_602_43# 0.03186f
C1129 g0_inv a_174_260# 0
C1130 clk a_880_69# 0.00836f
C1131 vdd a_21_42# 0.00148f
C1132 vdd w_740_467# 0.04561f
C1133 c0_inv vdd 0
C1134 a_441_300# gnd 0.0186f
C1135 w_684_8# a_687_87# 0.02689f
C1136 temp108 vdd 0.00103f
C1137 a_743_546# gnd 0.00473f
C1138 a_21_136# vdd 0.00155f
C1139 c0 a2 0.01629f
C1140 g0_inv w_88_314# 0.02763f
C1141 s3 mid_s3 0.00216f
C1142 temp102 a_220_353# 0.04407f
C1143 a_654_511# a_654_485# 0.03186f
C1144 w_517_8# a3 0.00153f
C1145 w_883_182# b4_inv 0.00602f
C1146 a_309_597# w_306_493# 0.03401f
C1147 a_973_272# g4_inv 0.18329f
C1148 s3 p2_inv 0.00926f
C1149 c0_inv a_125_272# 0.11558f
C1150 p2_inv b2 0.1865f
C1151 g1_inv temp103 0.17799f
C1152 c3 w_419_492# 0.00603f
C1153 gnd a_266_69# 0.00145f
C1154 vdd a_348_70# 0.00148f
C1155 clk a_100_67# 0.00836f
C1156 a_690_556# c4_in 0
C1157 vdd w_509_581# 0.04561f
C1158 temp110 vdd 0.00232f
C1159 a_359_313# gnd 0.22112f
C1160 a_838_568# gnd 0.00473f
C1161 a_945_268# w_908_310# 0.02507f
C1162 a_848_245# w_837_269# 0.00598f
C1163 a_635_221# gnd 0
C1164 c1 a_222_261# 0.03403f
C1165 c0 b0_inv 0
C1166 p0_inv b0 0.18651f
C1167 temp102 w_281_365# 0.00218f
C1168 s2_inv s2_out 0.04402f
C1169 p1_inv p0_inv 0.23101f
C1170 a_308_622# w_306_493# 0.03596f
C1171 temp109 a_441_300# 0.05029f
C1172 a_107_477# w_104_373# 0.03401f
C1173 w_684_8# b3_in 0.0205f
C1174 vdd a_603_87# 0.0012f
C1175 gnd a_520_87# 0.00473f
C1176 g2_inv a_760_348# 0.11558f
C1177 s1 w_211_285# 0.01368f
C1178 a_660_386# vdd 0
C1179 c0 w_676_255# 0.02076f
C1180 a_640_359# gnd 0.04275f
C1181 temp107 temp106 0
C1182 a_873_595# gnd 0
C1183 a_838_593# vdd 0.00127f
C1184 s3 clk 0.07184f
C1185 a_300_171# vdd 0
C1186 a_334_218# gnd 0
C1187 a_259_438# vdd 0
C1188 s1 w_104_373# 0.02405f
C1189 a_7_439# gnd 0.00483f
C1190 w_180_9# b0 0.02418f
C1191 w_223_186# b1 0.16256f
C1192 a_21_68# a_21_42# 0.03186f
C1193 temp110 g3_inv 0.00141f
C1194 a_654_485# c4_in 0.03201f
C1195 vdd a_349_88# 0.0012f
C1196 clk a_101_85# 0.02938f
C1197 gnd a_267_87# 0.00473f
C1198 temp107 w_419_492# 0.02095f
C1199 a_654_485# vdd 0.00148f
C1200 a_586_466# gnd 0.02012f
C1201 a_837_618# vdd 0.00155f
C1202 w_600_8# a_603_112# 0.03401f
C1203 a_838_568# a_837_550# 0.05922f
C1204 a_511_616# gnd 0.00167f
C1205 b0 gnd 0.02061f
C1206 c5 clk 0.07184f
C1207 p1_inv gnd 0.21936f
C1208 a_6_464# vdd 0.00155f
C1209 gnd b2_in 0.00153f
C1210 vdd a3_in 0.00151f
C1211 a_640_359# temp109 0.02579f
C1212 gnd a_22_86# 0.00473f
C1213 g2_inv c2 0.01044f
C1214 a_6_370# clk 0.08021f
C1215 g0_inv w_251_453# 0.0188f
C1216 c5_inv vdd 0
C1217 s2_out gnd 0.01932f
C1218 a_309_572# a_308_554# 0.05922f
C1219 s3 a_538_529# 0.00136f
C1220 a_945_296# vdd 0
C1221 a_848_245# gnd 0.12166f
C1222 a_841_502# vdd 0
C1223 a_742_502# gnd 0.00167f
C1224 clk a0_in 0.07609f
C1225 vdd b1_in 0.00149f
C1226 gnd a1_in 0.00153f
C1227 p4 w_676_255# 0.02295f
C1228 w_600_8# a_602_43# 0.02662f
C1229 vdd w_17_273# 0.00794f
C1230 gnd a_808_114# 0
C1231 temp106 a_535_452# 0.00254f
C1232 a_106_408# gnd 0.00167f
C1233 mid_s2 b2 0.00216f
C1234 c0 vdd 0.14501f
C1235 p3_inv a3 0.04811f
C1236 temp103 w_251_453# 0.03721f
C1237 p1_inv w_522_446# 0.0188f
C1238 s3_out vdd 0.00149f
C1239 w_878_8# clk 0.05738f
C1240 w_98_6# a_101_110# 0.03401f
C1241 s3_inv gnd 0
C1242 mid_s3 gnd 0.07579f
C1243 vdd w_4_335# 0.04561f
C1244 b3_inv a3 0.03149f
C1245 a_538_519# vdd 0
C1246 a_655_529# clk 0.02938f
C1247 p2_inv gnd 0.10977f
C1248 a_101_85# a_100_67# 0.05922f
C1249 gnd c0_in 0.00153f
C1250 vdd a_104_19# 0
C1251 c1 a_359_313# 0.00476f
C1252 p0_inv mid_s1 0
C1253 vdd w_208_373# 0.02075f
C1254 gnd a_470_115# 0
C1255 vdd a_101_110# 0.00127f
C1256 c4_out a_654_579# 0.05934f
C1257 a_654_511# w_652_450# 0.0271f
C1258 a_837_524# w_835_489# 0.02662f
C1259 s1_inv w_104_373# 0.00611f
C1260 w_346_9# vdd 0.0391f
C1261 w_19_7# a_22_111# 0.03401f
C1262 w_180_9# clk 0.05736f
C1263 temp108 g1_inv 0.00445f
C1264 vdd a_884_45# 0
C1265 c0_inv w_88_314# 0.03794f
C1266 temp109 w_429_320# 0.027f
C1267 p0_inv temp101 0.02579f
C1268 c0 g3_inv 0.00377f
C1269 w_98_6# a_100_41# 0.02662f
C1270 w_878_8# a_880_69# 0.0271f
C1271 gnd clk 21.33116f
C1272 p2_inv w_522_446# 0.03954f
C1273 w_346_9# a_348_138# 0.03596f
C1274 p2_inv temp109 0.02579f
C1275 w_524_189# vdd 0.05711f
C1276 temp108 a_450_500# 0
C1277 vdd a_100_41# 0.00148f
C1278 mid_s1 gnd 0.02014f
C1279 p4 vdd 0.00247f
C1280 a_359_313# w_348_337# 0.00598f
C1281 s0 w_17_273# 0.0154f
C1282 c0 s0 0.24886f
C1283 c1 a_586_466# 0.05029f
C1284 a_379_391# c2 0.04402f
C1285 w_517_8# a_519_69# 0.0271f
C1286 w_19_7# a_21_42# 0.02662f
C1287 a_430_473# vdd 0.00139f
C1288 s1_out gnd 0.01932f
C1289 a_308_528# clk 0.08021f
C1290 a_434_138# clk 0.00117f
C1291 a_519_137# vdd 0.00155f
C1292 a2 w_372_189# 0.08036f
C1293 s0 w_4_335# 0.02202f
C1294 c0 b3 0.02277f
C1295 w_19_7# a_21_136# 0.03596f
C1296 temp102 a_336_401# 0.00255f
C1297 p1_inv c1 0.01447f
C1298 b0_inv b0 0.06519f
C1299 c4_in w_652_450# 0.0205f
C1300 a_7_414# w_4_335# 0.02689f
C1301 vdd a_25_44# 0
C1302 clk a_772_69# 0.00836f
C1303 gnd a_880_69# 0.00145f
C1304 vdd w_652_450# 0.04561f
C1305 gnd w_573_460# 0.00177f
C1306 a_694_386# w_628_378# 0.03382f
C1307 temp101 gnd 0.02715f
C1308 p3_inv w_747_370# 0.0188f
C1309 a_441_300# vdd 0.00106f
C1310 a_743_546# vdd 0.0012f
C1311 a_837_550# clk 0.00836f
C1312 a_538_529# gnd 0.04227f
C1313 a_960_167# vdd 0
C1314 w_524_189# g3_inv 0.01272f
C1315 c0 a_140_171# 0.00379f
C1316 temp102 c0 0.00216f
C1317 a_434_70# a_434_44# 0.03186f
C1318 p2_inv a2 0.04811f
C1319 c0_inv a_125_300# 0
C1320 mid_s0 a_28_249# 0.16959f
C1321 g3_inv p4 0.00671f
C1322 gnd a_100_67# 0.00145f
C1323 clk a_182_70# 0.00836f
C1324 vdd a_266_69# 0.00148f
C1325 mid_s2 gnd 0.02f
C1326 a_359_313# vdd 0
C1327 temp106 g2_inv 0.00473f
C1328 a_743_571# clk 0.03055f
C1329 a_838_568# vdd 0.0012f
C1330 a_873_570# gnd 0
C1331 a_994_256# gnd 0
C1332 c0 b2_inv 0
C1333 p0_inv a0 0.04812f
C1334 temp102 w_208_373# 0.03572f
C1335 p2_inv c1 0.00883f
C1336 g1_inv a_336_401# 0
C1337 w_524_189# b3 0.16235f
C1338 mid_s4 a_848_245# 0.16959f
C1339 temp109 temp101 0.15571f
C1340 g2_inv w_419_492# 0.02076f
C1341 gnd a_916_89# 0
C1342 vdd a_520_87# 0.0012f
C1343 g2_inv a_760_376# 0
C1344 a_640_359# vdd 0.00148f
C1345 temp104 gnd 0.00452f
C1346 c0 s1 0.0016f
C1347 temp107 temp108 0.00105f
C1348 s3 gnd 0.00999f
C1349 a_742_596# clk 0.00117f
C1350 b4 a_960_167# 0
C1351 a_549_279# w_543_295# 0.00598f
C1352 a_686_43# b3_in 0.03186f
C1353 a3 a_602_137# 0.05946f
C1354 b2 gnd 0.02174f
C1355 a_42_441# gnd 0
C1356 a_7_439# vdd 0.00127f
C1357 a_107_452# clk 0.02938f
C1358 s1 a_222_261# 0
C1359 w_223_186# a1 0.08036f
C1360 w_98_6# b0 0
C1361 g1_inv c0 0.00401f
C1362 b4_in 0 0.14137f
C1363 a4_in 0 0.14137f
C1364 b3_in 0 0.14137f
C1365 a3_in 0 0.14137f
C1366 b2_in 0 0.14137f
C1367 a2_in 0 0.14137f
C1368 b1_in 0 0.14137f
C1369 a1_in 0 0.14137f
C1370 a0_in 0 0.14137f
C1371 b0_in 0 0.14137f
C1372 c0_in 0 0.14137f
C1373 a_880_43# 0 0.20136f
C1374 a_772_43# 0 0.20136f
C1375 a_686_43# 0 0.20136f
C1376 a_602_43# 0 0.20136f
C1377 a_519_43# 0 0.20136f
C1378 a_434_44# 0 0.20136f
C1379 a_348_44# 0 0.20136f
C1380 a_266_43# 0 0.20136f
C1381 a_100_41# 0 0.20136f
C1382 a_182_44# 0 0.20136f
C1383 a_21_42# 0 0.20136f
C1384 a_880_69# 0 0.27385f
C1385 a_772_69# 0 0.27385f
C1386 a_686_69# 0 0.27385f
C1387 a_602_69# 0 0.27385f
C1388 a_519_69# 0 0.27385f
C1389 a_434_70# 0 0.27385f
C1390 a_348_70# 0 0.27385f
C1391 a_266_69# 0 0.27385f
C1392 a_100_67# 0 0.27385f
C1393 a_182_70# 0 0.27385f
C1394 a_21_68# 0 0.27385f
C1395 a_881_87# 0 0.22767f
C1396 a_773_87# 0 0.22767f
C1397 a_687_87# 0 0.22767f
C1398 a_603_87# 0 0.22767f
C1399 a_520_87# 0 0.22767f
C1400 a_435_88# 0 0.22767f
C1401 a_349_88# 0 0.22767f
C1402 a_267_87# 0 0.22767f
C1403 a_101_85# 0 0.22767f
C1404 a_183_88# 0 0.22767f
C1405 a_22_86# 0 0.22767f
C1406 a_881_112# 0 0.23038f
C1407 a_773_112# 0 0.23038f
C1408 a_687_112# 0 0.23038f
C1409 a_603_112# 0 0.23038f
C1410 a_520_112# 0 0.23038f
C1411 a_435_113# 0 0.23038f
C1412 a_349_113# 0 0.23038f
C1413 a_267_112# 0 0.23038f
C1414 a_101_110# 0 0.23038f
C1415 a_183_113# 0 0.23038f
C1416 a_22_111# 0 0.23038f
C1417 clk 0 27.3627f
C1418 gnd 0 19.16121f
C1419 vdd 0 24.71608f
C1420 a_880_137# 0 0.26508f
C1421 a_772_137# 0 0.26508f
C1422 a_686_137# 0 0.26508f
C1423 a_602_137# 0 0.26508f
C1424 a_519_137# 0 0.26508f
C1425 a_776_139# 0 0.12326f
C1426 a_434_138# 0 0.26508f
C1427 a_348_138# 0 0.26508f
C1428 a_266_137# 0 0.26508f
C1429 a_100_135# 0 0.26508f
C1430 a_182_138# 0 0.26508f
C1431 a_21_136# 0 0.26508f
C1432 b4 0 2.12593f
C1433 a4 0 1.48474f
C1434 b4_inv 0 0.65629f
C1435 b3 0 3.5325f
C1436 a3 0 2.59006f
C1437 b3_inv 0 0.64037f
C1438 b2 0 2.74849f
C1439 a2 0 2.39175f
C1440 b1 0 3.18256f
C1441 a1 0 2.39686f
C1442 b1_inv 0 0.68166f
C1443 b0 0 3.22595f
C1444 a0 0 2.38163f
C1445 b0_inv 0 0.65629f
C1446 b2_inv 0 0.68166f
C1447 g4_inv 0 2.02335f
C1448 a_973_272# 0 0.25495f
C1449 a_945_268# 0 0.24377f
C1450 a_848_245# 0 0.80358f
C1451 temp113 0 0.32376f
C1452 mid_s4 0 1.00919f
C1453 a_549_279# 0 0.78946f
C1454 a_222_261# 0 0.7932f
C1455 mid_s3 0 1.99026f
C1456 c4_inv 0 0.39259f
C1457 p4_inv 0 1.48035f
C1458 c4_in 0 2.65413f
C1459 temp112 0 1.01015f
C1460 p4 0 2.01294f
C1461 mid_s1 0 1.36715f
C1462 temp100 0 0.25495f
C1463 a_125_272# 0 0.24377f
C1464 a_28_249# 0 0.80358f
C1465 mid_s0 0 1.00919f
C1466 c0_inv 0 0.31184f
C1467 a_441_300# 0 0.26925f
C1468 temp101 0 0.55593f
C1469 temp109 0 0.77324f
C1470 g3_inv 0 0.9004f
C1471 temp111 0 0.27751f
C1472 a_760_348# 0 0.24377f
C1473 temp110 0 1.13608f
C1474 a_359_313# 0 0.60245f
C1475 mid_s2 0 2.31985f
C1476 s0 0 1.38615f
C1477 a_694_386# 0 0.26925f
C1478 p3_inv 0 4.48224f
C1479 a_640_359# 0 0.24377f
C1480 temp104 0 0.78089f
C1481 s4 0 3.66559f
C1482 c2 0 1.35922f
C1483 a_654_485# 0 0.20136f
C1484 a_586_466# 0 0.26925f
C1485 c1 0 3.04152f
C1486 temp105 0 0.34829f
C1487 a_379_391# 0 0.24377f
C1488 a_6_370# 0 0.20136f
C1489 s1 0 3.5621f
C1490 a_6_396# 0 0.27385f
C1491 a_220_353# 0 0.26925f
C1492 c0 0 10.7962f
C1493 a_106_408# 0 0.20136f
C1494 p0_inv 0 2.16935f
C1495 a_7_414# 0 0.22767f
C1496 a_106_434# 0 0.27385f
C1497 g0_inv 0 1.21251f
C1498 a_7_439# 0 0.23038f
C1499 a_107_452# 0 0.22767f
C1500 temp102 0 1.37788f
C1501 a_231_438# 0 0.24377f
C1502 temp103 0 0.50763f
C1503 a_6_464# 0 0.26508f
C1504 p1_inv 0 4.92789f
C1505 c5 0 1.18472f
C1506 a_107_477# 0 0.23038f
C1507 s0_out 0 0.25665f
C1508 s0_inv 0 0.06313f
C1509 a_742_502# 0 0.20136f
C1510 a_654_511# 0 0.27385f
C1511 g1_inv 0 1.99477f
C1512 a_837_524# 0 0.20136f
C1513 a_742_528# 0 0.27385f
C1514 p2_inv 0 2.79076f
C1515 a_655_529# 0 0.22767f
C1516 c3 0 2.68196f
C1517 a_106_502# 0 0.26508f
C1518 s2 0 1.05206f
C1519 a_430_473# 0 0.24377f
C1520 s1_out 0 0.25665f
C1521 a_308_528# 0 0.20136f
C1522 s1_inv 0 0.06313f
C1523 g2_inv 0 7.75702f
C1524 temp106 0 1.5675f
C1525 temp108 0 0.36882f
C1526 a_743_546# 0 0.22767f
C1527 a_538_529# 0 0.24377f
C1528 a_837_550# 0 0.27385f
C1529 temp107 0 0.50763f
C1530 a_655_554# 0 0.23038f
C1531 a_308_554# 0 0.27385f
C1532 a_838_568# 0 0.22767f
C1533 a_743_571# 0 0.23038f
C1534 a_309_572# 0 0.22767f
C1535 a_654_579# 0 0.26508f
C1536 a_838_593# 0 0.23038f
C1537 s3 0 1.64589f
C1538 a_742_596# 0 0.26508f
C1539 a_309_597# 0 0.23038f
C1540 c4_out 0 0.25665f
C1541 a_837_618# 0 0.26508f
C1542 a_511_616# 0 0.20136f
C1543 s4_out 0 0.25665f
C1544 s4_inv 0 0.06313f
C1545 a_308_622# 0 0.26508f
C1546 c5_out 0 0.25665f
C1547 a_511_642# 0 0.27385f
C1548 c5_inv 0 0.06313f
C1549 s2_out 0 0.25665f
C1550 s2_inv 0 0.06313f
C1551 a_512_660# 0 0.22767f
C1552 a_512_685# 0 0.23038f
C1553 a_511_710# 0 0.26508f
C1554 s3_out 0 0.25665f
C1555 s3_inv 0 0.06313f
C1556 w_878_8# 0 4.56399f
C1557 w_770_8# 0 4.56399f
C1558 w_684_8# 0 4.56399f
C1559 w_600_8# 0 4.56399f
C1560 w_517_8# 0 4.56399f
C1561 w_432_9# 0 4.56399f
C1562 w_346_9# 0 4.56399f
C1563 w_264_8# 0 4.56399f
C1564 w_180_9# 0 4.56399f
C1565 w_98_6# 0 4.56399f
C1566 w_19_7# 0 4.56399f
C1567 w_883_182# 0 4.92256f
C1568 w_223_186# 0 4.92256f
C1569 w_63_186# 0 4.92256f
C1570 w_524_189# 0 4.92256f
C1571 w_372_189# 0 4.92256f
C1572 w_837_269# 0 1.96059f
C1573 w_676_255# 0 2.18557f
C1574 w_908_310# 0 4.13411f
C1575 w_728_296# 0 1.77578f
C1576 w_543_295# 0 1.96059f
C1577 w_211_285# 0 1.96059f
C1578 w_17_273# 0 1.96059f
C1579 w_429_320# 0 3.69017f
C1580 w_806_368# 0 1.09279f
C1581 w_348_337# 0 1.96059f
C1582 w_88_314# 0 4.13411f
C1583 w_747_370# 0 2.39851f
C1584 w_628_378# 0 4.18433f
C1585 w_281_365# 0 1.77578f
C1586 w_208_373# 0 1.81796f
C1587 w_835_489# 0 5.36751f
C1588 w_740_467# 0 5.36751f
C1589 w_652_450# 0 5.36751f
C1590 w_573_460# 0 1.81796f
C1591 w_522_446# 0 1.77578f
C1592 w_323_433# 0 3.74842f
C1593 w_251_453# 0 2.39851f
C1594 w_532_506# 0 2.39851f
C1595 w_419_492# 0 3.74842f
C1596 w_509_581# 0 5.36751f
C1597 w_306_493# 0 5.36751f
C1598 w_104_373# 0 5.36751f
C1599 w_4_335# 0 5.36751f

* Power Supply
Vdd vdd gnd 'SUPPLY'

* Clock Signal
Vclk clk gnd pulse 0 1.8 0 0.01ns 0.01ns 0.5ns 1ns

* Test Case 1: 15 + 10 + 0 = 25
* A = 01111, B = 01010, Cin = 0
Va0_in a0_in gnd pulse 1.8 0 2ns 10ps 10ps 10ns 20ns
Va1_in a1_in gnd pulse 1.8 0 2ns 10ps 10ps 10ns 20ns
Va2_in a2_in gnd pulse 1.8 0 2ns 10ps 10ps 10ns 20ns
Va3_in a3_in gnd pulse 1.8 0 2ns 10ps 10ps 10ns 20ns
Va4_in a4_in gnd pulse 0 1.8 2ns 10ps 10ps 10ns 20ns

Vb0_in b0_in gnd pulse 0 1.8 2ns 10ps 10ps 10ns 20ns
Vb1_in b1_in gnd pulse 1.8 0 2ns 10ps 10ps 10ns 20ns
Vb2_in b2_in gnd pulse 0 1.8 2ns 10ps 10ps 10ns 20ns
Vb3_in b3_in gnd pulse 1.8 0 2ns 10ps 10ps 10ns 20ns
Vb4_in b4_in gnd pulse 0 1.8 2ns 10ps 10ps 10ns 20ns

Vc0_in c0_in gnd pulse 0 1.8 2ns 10ps 10ps 10ns 20ns

* Measurements
.measure tran tpd_rise
+ TRIG v(a0_in) VAL='0.5*SUPPLY' RISE=1
+ TARG v(s4_out) VAL='0.5*SUPPLY' RISE=1

.measure tran tpd_fall
+ TRIG v(a0_in) VAL='0.5*SUPPLY' FALL=1
+ TARG v(s4_out) VAL='0.5*SUPPLY' FALL=1

.measure tran tpd param='(tpd_rise + tpd_fall)/2'

.measure tran avg_power avg p(Vdd) from=0ns to=20ns
.measure tran peak_power max p(Vdd) from=0ns to=20ns

.tran 10ps 20ns

.control
set hcopypscolor = 1
set color0=white
set color1=black
run
set curplottitle="5bit_CLA_Magic_Verification 2025122009"

plot v(a0_in), v(a1_in)+2, v(a2_in)+4, v(a3_in)+6, v(a4_in)+8, v(clk)+10
plot v(b0_in), v(b1_in)+2, v(b2_in)+4, v(b3_in)+6, v(b4_in)+8, v(c0_in)+10, v(clk)+12
plot v(s0_out), v(s1_out)+2, v(s2_out)+4, v(s3_out)+6, v(s4_out)+8, v(c5_out)+10, v(clk)+12

print tpd avg_power peak_power
.endc

.end
