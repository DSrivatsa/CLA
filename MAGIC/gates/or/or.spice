* SPICE3 file created from or.ext - technology: scmos

.option scale=1u

M1000 a_n11_40# in1 a_n18_40# w_n24_34# pfet w=40 l=2
+  ad=0.16n pd=48u as=0.2n ps=90u
M1001 out a_n11_12# gnd Gnd nfet w=10 l=2
+  ad=50p pd=30u as=50p ps=30u
M1002 gnd in2 a_n11_12# Gnd nfet w=10 l=2
+  ad=50p pd=30u as=40p ps=18u
M1003 out a_n11_12# a_n18_40# w_n24_34# pfet w=20 l=2
+  ad=100p pd=50u as=100p ps=50u
M1004 a_n11_12# in1 gnd Gnd nfet w=10 l=2
+  ad=40p pd=18u as=50p ps=30u
M1005 a_n11_12# in2 a_n11_40# w_n24_34# pfet w=40 l=2
+  ad=0.2n pd=90u as=0.16n ps=48u
C0 a_n18_40# w_n24_34# 1.692f
C1 in1 w_n24_34# 0.702f
C2 a_n11_12# w_n24_34# 1.548f
C3 in2 in1 0.18f
C4 in2 w_n24_34# 0.702f
C5 in2 a_n11_12# 0.18f
C6 out w_n24_34# 0.846f
C7 gnd 0 7.473f **FLOATING
C8 out 0 1.833f **FLOATING
C9 a_n11_12# 0 9.472f **FLOATING
C10 a_n18_40# 0 10.857f **FLOATING
C11 in2 0 9.349f **FLOATING
C12 in1 0 8.221f **FLOATING
